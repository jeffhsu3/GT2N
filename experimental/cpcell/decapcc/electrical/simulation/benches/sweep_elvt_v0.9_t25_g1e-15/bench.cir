GT2N decap extracted capacitance and model leakage
.INCLUDE "/home/jeff/iv4/repos/GT2N/experimental/cpcell/decapcc/electrical/simulation/models_elvt.inc"
* Partial PEX: 3D M0/V0/M1/BPR Maxwell capacitance; GT2 dielectric interfaces; GATE/SDCON/BPR/M0/M1 sheet and VG/VSD/V0/VBPR contact resistance. BSIM-CMG supplies intrinsic/overlap/fringe device C. Additional FEOL, VG/VSD/VBPR C, diffusion spreading R, neighboring cells, and chip/package environment are not extracted. Far-field reference is tied to vss.
.SUBCKT decap_ideal vdd vss
M1 net7 net12 vss vss nmos_elvt L=0.014u
M2 vdd net7 net12 vdd pmos_elvt L=0.014u
.ENDS decap_ideal

* Partial PEX: 3D M0/V0/M1/BPR Maxwell capacitance; GT2 dielectric interfaces; GATE/SDCON/BPR/M0/M1 sheet and VG/VSD/V0/VBPR contact resistance. BSIM-CMG supplies intrinsic/overlap/fringe device C. Additional FEOL, VG/VSD/VBPR C, diffusion spreading R, neighboring cells, and chip/package environment are not extracted. Far-field reference is tied to vss.
.SUBCKT decap_rc vdd vss
M1 net7_SDCON_8 net12_GATE_25 vss_SDCON_14 vss nmos_elvt L=0.014u
M2 vdd_SDCON_12 net7_GATE_14 net12_SDCON_8 vdd pmos_elvt L=0.014u
R0 net12_GATE_0 net12_GATE_1 6.70805357143
R1 net12_GATE_0 net12_GATE_20 7.49161538462
R2 net12_GATE_1 net12_GATE_2 6.70805357143
R3 net12_GATE_1 net12_GATE_21 6.9565
R4 net12_GATE_2 net12_GATE_3 6.70805357143
R5 net12_GATE_2 net12_GATE_22 7.49161538462
R6 net12_GATE_3 net12_GATE_4 6.70805357143
R7 net12_GATE_3 net12_GATE_23 6.9565
R8 net12_GATE_4 net12_GATE_5 6.45960714286
R9 net12_GATE_4 net12_GATE_24 7.49161538462
R10 net12_GATE_5 net12_GATE_6 6.70805357143
R11 net12_GATE_5 net12_GATE_25 7.49161538462
R12 net12_GATE_6 net12_GATE_7 6.70805357143
R13 net12_GATE_6 net12_GATE_26 6.9565
R14 net12_GATE_7 net12_GATE_8 6.70805357143
R15 net12_GATE_7 net12_GATE_27 7.49161538462
R16 net12_GATE_8 net12_GATE_9 6.70805357143
R17 net12_GATE_8 net12_GATE_28 6.9565
R18 net12_GATE_9 net12_GATE_10 6.45960714286
R19 net12_GATE_9 net12_GATE_29 7.49161538462
R20 net12_GATE_10 net12_GATE_11 6.70805357143
R21 net12_GATE_10 net12_GATE_30 7.49161538462
R22 net12_GATE_11 net12_GATE_12 6.70805357143
R23 net12_GATE_11 net12_GATE_31 6.9565
R24 net12_GATE_12 net12_GATE_13 6.70805357143
R25 net12_GATE_12 net12_GATE_32 7.49161538462
R26 net12_GATE_13 net12_GATE_14 6.70805357143
R27 net12_GATE_13 net12_GATE_33 6.9565
R28 net12_GATE_14 net12_GATE_15 6.45960714286
R29 net12_GATE_14 net12_GATE_34 7.49161538462
R30 net12_GATE_15 net12_GATE_16 6.70805357143
R31 net12_GATE_15 net12_GATE_35 7.49161538462
R32 net12_GATE_16 net12_GATE_17 6.70805357143
R33 net12_GATE_16 net12_GATE_36 6.9565
R34 net12_GATE_17 net12_GATE_18 6.70805357143
R35 net12_GATE_17 net12_GATE_37 7.49161538462
R36 net12_GATE_18 net12_GATE_19 6.70805357143
R37 net12_GATE_18 net12_GATE_38 6.9565
R38 net12_GATE_19 net12_GATE_39 7.49161538462
R39 net12_GATE_20 net12_GATE_21 6.70805357143
R40 net12_GATE_21 net12_GATE_22 6.70805357143
R41 net12_GATE_22 net12_GATE_23 6.70805357143
R42 net12_GATE_23 net12_GATE_24 6.70805357143
R43 net12_GATE_24 net12_GATE_25 6.45960714286
R44 net12_GATE_25 net12_GATE_26 6.70805357143
R45 net12_GATE_26 net12_GATE_27 6.70805357143
R46 net12_GATE_27 net12_GATE_28 6.70805357143
R47 net12_GATE_28 net12_GATE_29 6.70805357143
R48 net12_GATE_29 net12_GATE_30 6.45960714286
R49 net12_GATE_30 net12_GATE_31 6.70805357143
R50 net12_GATE_31 net12_GATE_32 6.70805357143
R51 net12_GATE_32 net12_GATE_33 6.70805357143
R52 net12_GATE_33 net12_GATE_34 6.70805357143
R53 net12_GATE_34 net12_GATE_35 6.45960714286
R54 net12_GATE_35 net12_GATE_36 6.70805357143
R55 net12_GATE_36 net12_GATE_37 6.70805357143
R56 net12_GATE_37 net12_GATE_38 6.70805357143
R57 net12_GATE_38 net12_GATE_39 6.70805357143
R58 net12_SDCON_0 net12_SDCON_1 15.3409090909
R59 net12_SDCON_0 net12_SDCON_6 9.375
R60 net12_SDCON_1 net12_SDCON_2 15.3409090909
R61 net12_SDCON_1 net12_SDCON_7 10.0961538462
R62 net12_SDCON_2 net12_SDCON_3 15.9090909091
R63 net12_SDCON_2 net12_SDCON_8 9.375
R64 net12_SDCON_3 net12_SDCON_4 15.3409090909
R65 net12_SDCON_3 net12_SDCON_9 9.375
R66 net12_SDCON_4 net12_SDCON_5 15.3409090909
R67 net12_SDCON_4 net12_SDCON_10 10.0961538462
R68 net12_SDCON_5 net12_SDCON_11 9.375
R69 net12_SDCON_6 net12_SDCON_7 16.875
R70 net12_SDCON_6 net12_SDCON_12 9.375
R71 net12_SDCON_7 net12_SDCON_8 16.875
R72 net12_SDCON_7 net12_SDCON_13 10.0961538462
R73 net12_SDCON_8 net12_SDCON_9 17.5
R74 net12_SDCON_8 net12_SDCON_14 9.375
R75 net12_SDCON_9 net12_SDCON_10 16.875
R76 net12_SDCON_9 net12_SDCON_15 9.375
R77 net12_SDCON_10 net12_SDCON_11 16.875
R78 net12_SDCON_10 net12_SDCON_16 10.0961538462
R79 net12_SDCON_11 net12_SDCON_17 9.375
R80 net12_SDCON_12 net12_SDCON_13 15.3409090909
R81 net12_SDCON_13 net12_SDCON_14 15.3409090909
R82 net12_SDCON_14 net12_SDCON_15 15.9090909091
R83 net12_SDCON_15 net12_SDCON_16 15.3409090909
R84 net12_SDCON_16 net12_SDCON_17 15.3409090909
R85 net12_M0_0 net12_M0_1 6.88707692308
R86 net12_M0_0 net12_M0_2 8.08275
R87 net12_M0_1 net12_M0_3 8.08275
R88 net12_M0_2 net12_M0_3 6.88707692308
R89 net12_M0_2 net12_M0_4 8.08275
R90 net12_M0_3 net12_M0_5 8.08275
R91 net12_M0_4 net12_M0_5 6.88707692308
R92 net12_M0_4 net12_M0_6 7.771875
R93 net12_M0_5 net12_M0_7 7.771875
R94 net12_M0_6 net12_M0_7 7.461
R95 net12_M0_6 net12_M0_8 7.771875
R96 net12_M0_7 net12_M0_9 7.771875
R97 net12_M0_8 net12_M0_9 6.88707692308
R98 net12_M0_8 net12_M0_10 8.08275
R99 net12_M0_9 net12_M0_11 8.08275
R100 net12_M0_10 net12_M0_11 6.88707692308
R101 net12_M0_10 net12_M0_12 8.08275
R102 net12_M0_11 net12_M0_13 8.08275
R103 net12_M0_12 net12_M0_13 6.88707692308
R104 net12_M0_14 net12_M0_15 6.88707692308
R105 net12_M0_14 net12_M0_16 8.08275
R106 net12_M0_15 net12_M0_17 8.08275
R107 net12_M0_16 net12_M0_17 6.88707692308
R108 net12_M0_16 net12_M0_18 8.393625
R109 net12_M0_17 net12_M0_19 8.393625
R110 net12_M0_18 net12_M0_19 6.39514285714
R111 net12_M0_18 net12_M0_20 8.393625
R112 net12_M0_19 net12_M0_21 8.393625
R113 net12_M0_20 net12_M0_21 6.88707692308
R114 net12_M0_20 net12_M0_22 8.08275
R115 net12_M0_21 net12_M0_23 8.08275
R116 net12_M0_22 net12_M0_23 6.88707692308
R117 net12_M0_22 net12_M0_24 8.08275
R118 net12_M0_23 net12_M0_25 8.08275
R119 net12_M0_24 net12_M0_25 6.88707692308
R120 net12_M0_24 net12_M0_26 8.08275
R121 net12_M0_25 net12_M0_27 8.08275
R122 net12_M0_26 net12_M0_27 6.88707692308
R123 net12_M0_26 net12_M0_28 8.393625
R124 net12_M0_27 net12_M0_29 8.393625
R125 net12_M0_28 net12_M0_29 6.39514285714
R126 net12_M0_28 net12_M0_30 8.393625
R127 net12_M0_29 net12_M0_31 8.393625
R128 net12_M0_30 net12_M0_31 6.88707692308
R129 net12_M0_30 net12_M0_32 8.08275
R130 net12_M0_31 net12_M0_33 8.08275
R131 net12_M0_32 net12_M0_33 6.88707692308
R132 net12_M1_0 net12_M1_1 5.46875
R133 net12_M1_0 net12_M1_7 6.59615384615
R134 net12_M1_1 net12_M1_2 5.46875
R135 net12_M1_1 net12_M1_8 7.14583333333
R136 net12_M1_2 net12_M1_3 5.46875
R137 net12_M1_2 net12_M1_9 6.59615384615
R138 net12_M1_3 net12_M1_4 5.46875
R139 net12_M1_3 net12_M1_10 7.14583333333
R140 net12_M1_4 net12_M1_5 5.46875
R141 net12_M1_4 net12_M1_11 6.59615384615
R142 net12_M1_5 net12_M1_6 5.46875
R143 net12_M1_5 net12_M1_12 7.14583333333
R144 net12_M1_6 net12_M1_13 6.59615384615
R145 net12_M1_7 net12_M1_8 5.46875
R146 net12_M1_8 net12_M1_9 5.46875
R147 net12_M1_9 net12_M1_10 5.46875
R148 net12_M1_10 net12_M1_11 5.46875
R149 net12_M1_11 net12_M1_12 5.46875
R150 net12_M1_12 net12_M1_13 5.46875
R151 net12_GATE_10 net12_M0_2 34.2214285714
R152 net12_SDCON_8 net12_M0_30 36.86
R153 net12_M0_10 net12_M1_1 54.99
R154 net12_M0_16 net12_M1_12 54.99
R155 net7_GATE_0 net7_GATE_1 6.70805357143
R156 net7_GATE_0 net7_GATE_20 7.49161538462
R157 net7_GATE_1 net7_GATE_2 6.70805357143
R158 net7_GATE_1 net7_GATE_21 6.9565
R159 net7_GATE_2 net7_GATE_3 6.70805357143
R160 net7_GATE_2 net7_GATE_22 7.49161538462
R161 net7_GATE_3 net7_GATE_4 6.70805357143
R162 net7_GATE_3 net7_GATE_23 6.9565
R163 net7_GATE_4 net7_GATE_5 6.45960714286
R164 net7_GATE_4 net7_GATE_24 7.49161538462
R165 net7_GATE_5 net7_GATE_6 6.70805357143
R166 net7_GATE_5 net7_GATE_25 7.49161538462
R167 net7_GATE_6 net7_GATE_7 6.70805357143
R168 net7_GATE_6 net7_GATE_26 6.9565
R169 net7_GATE_7 net7_GATE_8 6.70805357143
R170 net7_GATE_7 net7_GATE_27 7.49161538462
R171 net7_GATE_8 net7_GATE_9 6.70805357143
R172 net7_GATE_8 net7_GATE_28 6.9565
R173 net7_GATE_9 net7_GATE_10 6.45960714286
R174 net7_GATE_9 net7_GATE_29 7.49161538462
R175 net7_GATE_10 net7_GATE_11 6.70805357143
R176 net7_GATE_10 net7_GATE_30 7.49161538462
R177 net7_GATE_11 net7_GATE_12 6.70805357143
R178 net7_GATE_11 net7_GATE_31 6.9565
R179 net7_GATE_12 net7_GATE_13 6.70805357143
R180 net7_GATE_12 net7_GATE_32 7.49161538462
R181 net7_GATE_13 net7_GATE_14 6.70805357143
R182 net7_GATE_13 net7_GATE_33 6.9565
R183 net7_GATE_14 net7_GATE_15 6.45960714286
R184 net7_GATE_14 net7_GATE_34 7.49161538462
R185 net7_GATE_15 net7_GATE_16 6.70805357143
R186 net7_GATE_15 net7_GATE_35 7.49161538462
R187 net7_GATE_16 net7_GATE_17 6.70805357143
R188 net7_GATE_16 net7_GATE_36 6.9565
R189 net7_GATE_17 net7_GATE_18 6.70805357143
R190 net7_GATE_17 net7_GATE_37 7.49161538462
R191 net7_GATE_18 net7_GATE_19 6.70805357143
R192 net7_GATE_18 net7_GATE_38 6.9565
R193 net7_GATE_19 net7_GATE_39 7.49161538462
R194 net7_GATE_20 net7_GATE_21 6.70805357143
R195 net7_GATE_21 net7_GATE_22 6.70805357143
R196 net7_GATE_22 net7_GATE_23 6.70805357143
R197 net7_GATE_23 net7_GATE_24 6.70805357143
R198 net7_GATE_24 net7_GATE_25 6.45960714286
R199 net7_GATE_25 net7_GATE_26 6.70805357143
R200 net7_GATE_26 net7_GATE_27 6.70805357143
R201 net7_GATE_27 net7_GATE_28 6.70805357143
R202 net7_GATE_28 net7_GATE_29 6.70805357143
R203 net7_GATE_29 net7_GATE_30 6.45960714286
R204 net7_GATE_30 net7_GATE_31 6.70805357143
R205 net7_GATE_31 net7_GATE_32 6.70805357143
R206 net7_GATE_32 net7_GATE_33 6.70805357143
R207 net7_GATE_33 net7_GATE_34 6.70805357143
R208 net7_GATE_34 net7_GATE_35 6.45960714286
R209 net7_GATE_35 net7_GATE_36 6.70805357143
R210 net7_GATE_36 net7_GATE_37 6.70805357143
R211 net7_GATE_37 net7_GATE_38 6.70805357143
R212 net7_GATE_38 net7_GATE_39 6.70805357143
R213 net7_SDCON_0 net7_SDCON_1 15.3409090909
R214 net7_SDCON_0 net7_SDCON_6 9.375
R215 net7_SDCON_1 net7_SDCON_2 15.3409090909
R216 net7_SDCON_1 net7_SDCON_7 10.0961538462
R217 net7_SDCON_2 net7_SDCON_3 15.9090909091
R218 net7_SDCON_2 net7_SDCON_8 9.375
R219 net7_SDCON_3 net7_SDCON_4 15.3409090909
R220 net7_SDCON_3 net7_SDCON_9 9.375
R221 net7_SDCON_4 net7_SDCON_5 15.3409090909
R222 net7_SDCON_4 net7_SDCON_10 10.0961538462
R223 net7_SDCON_5 net7_SDCON_11 9.375
R224 net7_SDCON_6 net7_SDCON_7 16.875
R225 net7_SDCON_6 net7_SDCON_12 9.375
R226 net7_SDCON_7 net7_SDCON_8 16.875
R227 net7_SDCON_7 net7_SDCON_13 10.0961538462
R228 net7_SDCON_8 net7_SDCON_9 17.5
R229 net7_SDCON_8 net7_SDCON_14 9.375
R230 net7_SDCON_9 net7_SDCON_10 16.875
R231 net7_SDCON_9 net7_SDCON_15 9.375
R232 net7_SDCON_10 net7_SDCON_11 16.875
R233 net7_SDCON_10 net7_SDCON_16 10.0961538462
R234 net7_SDCON_11 net7_SDCON_17 9.375
R235 net7_SDCON_12 net7_SDCON_13 15.3409090909
R236 net7_SDCON_13 net7_SDCON_14 15.3409090909
R237 net7_SDCON_14 net7_SDCON_15 15.9090909091
R238 net7_SDCON_15 net7_SDCON_16 15.3409090909
R239 net7_SDCON_16 net7_SDCON_17 15.3409090909
R240 net7_M0_0 net7_M0_1 6.88707692308
R241 net7_M0_0 net7_M0_2 8.08275
R242 net7_M0_1 net7_M0_3 8.08275
R243 net7_M0_2 net7_M0_3 6.88707692308
R244 net7_M0_2 net7_M0_4 8.393625
R245 net7_M0_3 net7_M0_5 8.393625
R246 net7_M0_4 net7_M0_5 6.39514285714
R247 net7_M0_4 net7_M0_6 8.393625
R248 net7_M0_5 net7_M0_7 8.393625
R249 net7_M0_6 net7_M0_7 6.88707692308
R250 net7_M0_6 net7_M0_8 8.08275
R251 net7_M0_7 net7_M0_9 8.08275
R252 net7_M0_8 net7_M0_9 6.88707692308
R253 net7_M0_8 net7_M0_10 8.08275
R254 net7_M0_9 net7_M0_11 8.08275
R255 net7_M0_10 net7_M0_11 6.88707692308
R256 net7_M0_10 net7_M0_12 8.08275
R257 net7_M0_11 net7_M0_13 8.08275
R258 net7_M0_12 net7_M0_13 6.88707692308
R259 net7_M0_12 net7_M0_14 8.393625
R260 net7_M0_13 net7_M0_15 8.393625
R261 net7_M0_14 net7_M0_15 6.39514285714
R262 net7_M0_14 net7_M0_16 8.393625
R263 net7_M0_15 net7_M0_17 8.393625
R264 net7_M0_16 net7_M0_17 6.88707692308
R265 net7_M0_16 net7_M0_18 8.08275
R266 net7_M0_17 net7_M0_19 8.08275
R267 net7_M0_18 net7_M0_19 6.88707692308
R268 net7_M0_20 net7_M0_21 6.88707692308
R269 net7_M0_20 net7_M0_22 8.08275
R270 net7_M0_21 net7_M0_23 8.08275
R271 net7_M0_22 net7_M0_23 6.88707692308
R272 net7_M0_22 net7_M0_24 8.08275
R273 net7_M0_23 net7_M0_25 8.08275
R274 net7_M0_24 net7_M0_25 6.88707692308
R275 net7_M0_24 net7_M0_26 7.771875
R276 net7_M0_25 net7_M0_27 7.771875
R277 net7_M0_26 net7_M0_27 7.461
R278 net7_M0_26 net7_M0_28 7.771875
R279 net7_M0_27 net7_M0_29 7.771875
R280 net7_M0_28 net7_M0_29 6.88707692308
R281 net7_M0_28 net7_M0_30 8.08275
R282 net7_M0_29 net7_M0_31 8.08275
R283 net7_M0_30 net7_M0_31 6.88707692308
R284 net7_M0_30 net7_M0_32 8.08275
R285 net7_M0_31 net7_M0_33 8.08275
R286 net7_M0_32 net7_M0_33 6.88707692308
R287 net7_M1_0 net7_M1_1 5.46875
R288 net7_M1_0 net7_M1_7 6.59615384615
R289 net7_M1_1 net7_M1_2 5.46875
R290 net7_M1_1 net7_M1_8 7.14583333333
R291 net7_M1_2 net7_M1_3 5.46875
R292 net7_M1_2 net7_M1_9 6.59615384615
R293 net7_M1_3 net7_M1_4 5.46875
R294 net7_M1_3 net7_M1_10 7.14583333333
R295 net7_M1_4 net7_M1_5 5.46875
R296 net7_M1_4 net7_M1_11 6.59615384615
R297 net7_M1_5 net7_M1_6 5.46875
R298 net7_M1_5 net7_M1_12 7.14583333333
R299 net7_M1_6 net7_M1_13 6.59615384615
R300 net7_M1_7 net7_M1_8 5.46875
R301 net7_M1_8 net7_M1_9 5.46875
R302 net7_M1_9 net7_M1_10 5.46875
R303 net7_M1_10 net7_M1_11 5.46875
R304 net7_M1_11 net7_M1_12 5.46875
R305 net7_M1_12 net7_M1_13 5.46875
R306 net7_GATE_10 net7_M0_30 34.2214285714
R307 net7_SDCON_9 net7_M0_2 36.86
R308 net7_M0_16 net7_M1_1 54.99
R309 net7_M0_22 net7_M1_12 54.99
R310 vdd_SDCON_0 vdd_SDCON_1 14.2045454545
R311 vdd_SDCON_0 vdd_SDCON_9 10.0961538462
R312 vdd_SDCON_1 vdd_SDCON_2 14.2045454545
R313 vdd_SDCON_1 vdd_SDCON_10 10.9375
R314 vdd_SDCON_2 vdd_SDCON_3 14.7727272727
R315 vdd_SDCON_2 vdd_SDCON_11 10.0961538462
R316 vdd_SDCON_3 vdd_SDCON_4 14.2045454545
R317 vdd_SDCON_3 vdd_SDCON_12 10.0961538462
R318 vdd_SDCON_4 vdd_SDCON_5 14.2045454545
R319 vdd_SDCON_4 vdd_SDCON_13 10.9375
R320 vdd_SDCON_5 vdd_SDCON_6 14.7727272727
R321 vdd_SDCON_5 vdd_SDCON_14 10.0961538462
R322 vdd_SDCON_6 vdd_SDCON_7 14.2045454545
R323 vdd_SDCON_6 vdd_SDCON_15 10.0961538462
R324 vdd_SDCON_7 vdd_SDCON_8 14.2045454545
R325 vdd_SDCON_7 vdd_SDCON_16 10.9375
R326 vdd_SDCON_8 vdd_SDCON_17 10.0961538462
R327 vdd_SDCON_9 vdd_SDCON_10 15.625
R328 vdd_SDCON_9 vdd_SDCON_18 10.0961538462
R329 vdd_SDCON_10 vdd_SDCON_11 15.625
R330 vdd_SDCON_10 vdd_SDCON_19 10.9375
R331 vdd_SDCON_11 vdd_SDCON_12 16.25
R332 vdd_SDCON_11 vdd_SDCON_20 10.0961538462
R333 vdd_SDCON_12 vdd_SDCON_13 15.625
R334 vdd_SDCON_12 vdd_SDCON_21 10.0961538462
R335 vdd_SDCON_13 vdd_SDCON_14 15.625
R336 vdd_SDCON_13 vdd_SDCON_22 10.9375
R337 vdd_SDCON_14 vdd_SDCON_15 16.25
R338 vdd_SDCON_14 vdd_SDCON_23 10.0961538462
R339 vdd_SDCON_15 vdd_SDCON_16 15.625
R340 vdd_SDCON_15 vdd_SDCON_24 10.0961538462
R341 vdd_SDCON_16 vdd_SDCON_17 15.625
R342 vdd_SDCON_16 vdd_SDCON_25 10.9375
R343 vdd_SDCON_17 vdd_SDCON_26 10.0961538462
R344 vdd_SDCON_18 vdd_SDCON_19 14.2045454545
R345 vdd_SDCON_19 vdd_SDCON_20 14.2045454545
R346 vdd_SDCON_20 vdd_SDCON_21 14.7727272727
R347 vdd_SDCON_21 vdd_SDCON_22 14.2045454545
R348 vdd_SDCON_22 vdd_SDCON_23 14.2045454545
R349 vdd_SDCON_23 vdd_SDCON_24 14.7727272727
R350 vdd_SDCON_24 vdd_SDCON_25 14.2045454545
R351 vdd_SDCON_25 vdd_SDCON_26 14.2045454545
R352 vdd_BPR_0 vdd_BPR_1 0.722242857143
R353 vdd_BPR_0 vdd_BPR_5 0.837630769231
R354 vdd_BPR_1 vdd_BPR_2 0.694464285714
R355 vdd_BPR_1 vdd_BPR_6 0.837630769231
R356 vdd_BPR_2 vdd_BPR_3 0.694464285714
R357 vdd_BPR_2 vdd_BPR_7 0.907433333333
R358 vdd_BPR_3 vdd_BPR_4 0.722242857143
R359 vdd_BPR_3 vdd_BPR_8 0.837630769231
R360 vdd_BPR_4 vdd_BPR_9 0.837630769231
R361 vdd_BPR_5 vdd_BPR_6 0.722242857143
R362 vdd_BPR_5 vdd_BPR_10 0.837630769231
R363 vdd_BPR_6 vdd_BPR_7 0.694464285714
R364 vdd_BPR_6 vdd_BPR_11 0.837630769231
R365 vdd_BPR_7 vdd_BPR_8 0.694464285714
R366 vdd_BPR_7 vdd_BPR_12 0.907433333333
R367 vdd_BPR_8 vdd_BPR_9 0.722242857143
R368 vdd_BPR_8 vdd_BPR_13 0.837630769231
R369 vdd_BPR_9 vdd_BPR_14 0.837630769231
R370 vdd_BPR_10 vdd_BPR_11 0.722242857143
R371 vdd_BPR_10 vdd_BPR_15 0.837630769231
R372 vdd_BPR_11 vdd_BPR_12 0.694464285714
R373 vdd_BPR_11 vdd_BPR_16 0.837630769231
R374 vdd_BPR_12 vdd_BPR_13 0.694464285714
R375 vdd_BPR_12 vdd_BPR_17 0.907433333333
R376 vdd_BPR_13 vdd_BPR_14 0.722242857143
R377 vdd_BPR_13 vdd_BPR_18 0.837630769231
R378 vdd_BPR_14 vdd_BPR_19 0.837630769231
R379 vdd_BPR_15 vdd_BPR_16 0.722242857143
R380 vdd_BPR_15 vdd_BPR_20 0.837630769231
R381 vdd_BPR_16 vdd_BPR_17 0.694464285714
R382 vdd_BPR_16 vdd_BPR_21 0.837630769231
R383 vdd_BPR_17 vdd_BPR_18 0.694464285714
R384 vdd_BPR_17 vdd_BPR_22 0.907433333333
R385 vdd_BPR_18 vdd_BPR_19 0.722242857143
R386 vdd_BPR_18 vdd_BPR_23 0.837630769231
R387 vdd_BPR_19 vdd_BPR_24 0.837630769231
R388 vdd_BPR_20 vdd_BPR_21 0.722242857143
R389 vdd_BPR_20 vdd_BPR_25 0.837630769231
R390 vdd_BPR_21 vdd_BPR_22 0.694464285714
R391 vdd_BPR_21 vdd_BPR_26 0.837630769231
R392 vdd_BPR_22 vdd_BPR_23 0.694464285714
R393 vdd_BPR_22 vdd_BPR_27 0.907433333333
R394 vdd_BPR_23 vdd_BPR_24 0.722242857143
R395 vdd_BPR_23 vdd_BPR_28 0.837630769231
R396 vdd_BPR_24 vdd_BPR_29 0.837630769231
R397 vdd_BPR_25 vdd_BPR_26 0.722242857143
R398 vdd_BPR_25 vdd_BPR_30 0.837630769231
R399 vdd_BPR_26 vdd_BPR_27 0.694464285714
R400 vdd_BPR_26 vdd_BPR_31 0.837630769231
R401 vdd_BPR_27 vdd_BPR_28 0.694464285714
R402 vdd_BPR_27 vdd_BPR_32 0.907433333333
R403 vdd_BPR_28 vdd_BPR_29 0.722242857143
R404 vdd_BPR_28 vdd_BPR_33 0.837630769231
R405 vdd_BPR_29 vdd_BPR_34 0.837630769231
R406 vdd_BPR_30 vdd_BPR_31 0.722242857143
R407 vdd_BPR_30 vdd_BPR_35 0.837630769231
R408 vdd_BPR_31 vdd_BPR_32 0.694464285714
R409 vdd_BPR_31 vdd_BPR_36 0.837630769231
R410 vdd_BPR_32 vdd_BPR_33 0.694464285714
R411 vdd_BPR_32 vdd_BPR_37 0.907433333333
R412 vdd_BPR_33 vdd_BPR_34 0.722242857143
R413 vdd_BPR_33 vdd_BPR_38 0.837630769231
R414 vdd_BPR_34 vdd_BPR_39 0.837630769231
R415 vdd_BPR_35 vdd_BPR_36 0.722242857143
R416 vdd_BPR_35 vdd_BPR_40 0.837630769231
R417 vdd_BPR_36 vdd_BPR_37 0.694464285714
R418 vdd_BPR_36 vdd_BPR_41 0.837630769231
R419 vdd_BPR_37 vdd_BPR_38 0.694464285714
R420 vdd_BPR_37 vdd_BPR_42 0.907433333333
R421 vdd_BPR_38 vdd_BPR_39 0.722242857143
R422 vdd_BPR_38 vdd_BPR_43 0.837630769231
R423 vdd_BPR_39 vdd_BPR_44 0.837630769231
R424 vdd_BPR_40 vdd_BPR_41 0.722242857143
R425 vdd_BPR_40 vdd_BPR_45 0.837630769231
R426 vdd_BPR_41 vdd_BPR_42 0.694464285714
R427 vdd_BPR_41 vdd_BPR_46 0.837630769231
R428 vdd_BPR_42 vdd_BPR_43 0.694464285714
R429 vdd_BPR_42 vdd_BPR_47 0.907433333333
R430 vdd_BPR_43 vdd_BPR_44 0.722242857143
R431 vdd_BPR_43 vdd_BPR_48 0.837630769231
R432 vdd_BPR_44 vdd_BPR_49 0.837630769231
R433 vdd_BPR_45 vdd_BPR_46 0.722242857143
R434 vdd_BPR_45 vdd_BPR_50 0.837630769231
R435 vdd_BPR_46 vdd_BPR_47 0.694464285714
R436 vdd_BPR_46 vdd_BPR_51 0.837630769231
R437 vdd_BPR_47 vdd_BPR_48 0.694464285714
R438 vdd_BPR_47 vdd_BPR_52 0.907433333333
R439 vdd_BPR_48 vdd_BPR_49 0.722242857143
R440 vdd_BPR_48 vdd_BPR_53 0.837630769231
R441 vdd_BPR_49 vdd_BPR_54 0.837630769231
R442 vdd_BPR_50 vdd_BPR_51 0.722242857143
R443 vdd_BPR_50 vdd_BPR_55 0.837630769231
R444 vdd_BPR_51 vdd_BPR_52 0.694464285714
R445 vdd_BPR_51 vdd_BPR_56 0.837630769231
R446 vdd_BPR_52 vdd_BPR_53 0.694464285714
R447 vdd_BPR_52 vdd 0.907433333333
R448 vdd_BPR_53 vdd_BPR_54 0.722242857143
R449 vdd_BPR_53 vdd_BPR_58 0.837630769231
R450 vdd_BPR_54 vdd_BPR_59 0.837630769231
R451 vdd_BPR_55 vdd_BPR_56 0.722242857143
R452 vdd_BPR_55 vdd_BPR_60 0.837630769231
R453 vdd_BPR_56 vdd 0.694464285714
R454 vdd_BPR_56 vdd_BPR_61 0.837630769231
R455 vdd vdd_BPR_58 0.694464285714
R456 vdd vdd_BPR_62 0.907433333333
R457 vdd_BPR_58 vdd_BPR_59 0.722242857143
R458 vdd_BPR_58 vdd_BPR_63 0.837630769231
R459 vdd_BPR_59 vdd_BPR_64 0.837630769231
R460 vdd_BPR_60 vdd_BPR_61 0.722242857143
R461 vdd_BPR_60 vdd_BPR_65 0.837630769231
R462 vdd_BPR_61 vdd_BPR_62 0.694464285714
R463 vdd_BPR_61 vdd_BPR_66 0.837630769231
R464 vdd_BPR_62 vdd_BPR_63 0.694464285714
R465 vdd_BPR_62 vdd_BPR_67 0.907433333333
R466 vdd_BPR_63 vdd_BPR_64 0.722242857143
R467 vdd_BPR_63 vdd_BPR_68 0.837630769231
R468 vdd_BPR_64 vdd_BPR_69 0.837630769231
R469 vdd_BPR_65 vdd_BPR_66 0.722242857143
R470 vdd_BPR_65 vdd_BPR_70 0.837630769231
R471 vdd_BPR_66 vdd_BPR_67 0.694464285714
R472 vdd_BPR_66 vdd_BPR_71 0.837630769231
R473 vdd_BPR_67 vdd_BPR_68 0.694464285714
R474 vdd_BPR_67 vdd_BPR_72 0.907433333333
R475 vdd_BPR_68 vdd_BPR_69 0.722242857143
R476 vdd_BPR_68 vdd_BPR_73 0.837630769231
R477 vdd_BPR_69 vdd_BPR_74 0.837630769231
R478 vdd_BPR_70 vdd_BPR_71 0.722242857143
R479 vdd_BPR_70 vdd_BPR_75 0.837630769231
R480 vdd_BPR_71 vdd_BPR_72 0.694464285714
R481 vdd_BPR_71 vdd_BPR_76 0.837630769231
R482 vdd_BPR_72 vdd_BPR_73 0.694464285714
R483 vdd_BPR_72 vdd_BPR_77 0.907433333333
R484 vdd_BPR_73 vdd_BPR_74 0.722242857143
R485 vdd_BPR_73 vdd_BPR_78 0.837630769231
R486 vdd_BPR_74 vdd_BPR_79 0.837630769231
R487 vdd_BPR_75 vdd_BPR_76 0.722242857143
R488 vdd_BPR_75 vdd_BPR_80 0.837630769231
R489 vdd_BPR_76 vdd_BPR_77 0.694464285714
R490 vdd_BPR_76 vdd_BPR_81 0.837630769231
R491 vdd_BPR_77 vdd_BPR_78 0.694464285714
R492 vdd_BPR_77 vdd_BPR_82 0.907433333333
R493 vdd_BPR_78 vdd_BPR_79 0.722242857143
R494 vdd_BPR_78 vdd_BPR_83 0.837630769231
R495 vdd_BPR_79 vdd_BPR_84 0.837630769231
R496 vdd_BPR_80 vdd_BPR_81 0.722242857143
R497 vdd_BPR_80 vdd_BPR_85 0.837630769231
R498 vdd_BPR_81 vdd_BPR_82 0.694464285714
R499 vdd_BPR_81 vdd_BPR_86 0.837630769231
R500 vdd_BPR_82 vdd_BPR_83 0.694464285714
R501 vdd_BPR_82 vdd_BPR_87 0.907433333333
R502 vdd_BPR_83 vdd_BPR_84 0.722242857143
R503 vdd_BPR_83 vdd_BPR_88 0.837630769231
R504 vdd_BPR_84 vdd_BPR_89 0.837630769231
R505 vdd_BPR_85 vdd_BPR_86 0.722242857143
R506 vdd_BPR_85 vdd_BPR_90 0.837630769231
R507 vdd_BPR_86 vdd_BPR_87 0.694464285714
R508 vdd_BPR_86 vdd_BPR_91 0.837630769231
R509 vdd_BPR_87 vdd_BPR_88 0.694464285714
R510 vdd_BPR_87 vdd_BPR_92 0.907433333333
R511 vdd_BPR_88 vdd_BPR_89 0.722242857143
R512 vdd_BPR_88 vdd_BPR_93 0.837630769231
R513 vdd_BPR_89 vdd_BPR_94 0.837630769231
R514 vdd_BPR_90 vdd_BPR_91 0.722242857143
R515 vdd_BPR_90 vdd_BPR_95 0.837630769231
R516 vdd_BPR_91 vdd_BPR_92 0.694464285714
R517 vdd_BPR_91 vdd_BPR_96 0.837630769231
R518 vdd_BPR_92 vdd_BPR_93 0.694464285714
R519 vdd_BPR_92 vdd_BPR_97 0.907433333333
R520 vdd_BPR_93 vdd_BPR_94 0.722242857143
R521 vdd_BPR_93 vdd_BPR_98 0.837630769231
R522 vdd_BPR_94 vdd_BPR_99 0.837630769231
R523 vdd_BPR_95 vdd_BPR_96 0.722242857143
R524 vdd_BPR_95 vdd_BPR_100 0.837630769231
R525 vdd_BPR_96 vdd_BPR_97 0.694464285714
R526 vdd_BPR_96 vdd_BPR_101 0.837630769231
R527 vdd_BPR_97 vdd_BPR_98 0.694464285714
R528 vdd_BPR_97 vdd_BPR_102 0.907433333333
R529 vdd_BPR_98 vdd_BPR_99 0.722242857143
R530 vdd_BPR_98 vdd_BPR_103 0.837630769231
R531 vdd_BPR_99 vdd_BPR_104 0.837630769231
R532 vdd_BPR_100 vdd_BPR_101 0.722242857143
R533 vdd_BPR_100 vdd_BPR_105 0.837630769231
R534 vdd_BPR_101 vdd_BPR_102 0.694464285714
R535 vdd_BPR_101 vdd_BPR_106 0.837630769231
R536 vdd_BPR_102 vdd_BPR_103 0.694464285714
R537 vdd_BPR_102 vdd_BPR_107 0.907433333333
R538 vdd_BPR_103 vdd_BPR_104 0.722242857143
R539 vdd_BPR_103 vdd_BPR_108 0.837630769231
R540 vdd_BPR_104 vdd_BPR_109 0.837630769231
R541 vdd_BPR_105 vdd_BPR_106 0.722242857143
R542 vdd_BPR_105 vdd_BPR_110 0.837630769231
R543 vdd_BPR_106 vdd_BPR_107 0.694464285714
R544 vdd_BPR_106 vdd_BPR_111 0.837630769231
R545 vdd_BPR_107 vdd_BPR_108 0.694464285714
R546 vdd_BPR_107 vdd_BPR_112 0.907433333333
R547 vdd_BPR_108 vdd_BPR_109 0.722242857143
R548 vdd_BPR_108 vdd_BPR_113 0.837630769231
R549 vdd_BPR_109 vdd_BPR_114 0.837630769231
R550 vdd_BPR_110 vdd_BPR_111 0.722242857143
R551 vdd_BPR_110 vdd_BPR_115 0.837630769231
R552 vdd_BPR_111 vdd_BPR_112 0.694464285714
R553 vdd_BPR_111 vdd_BPR_116 0.837630769231
R554 vdd_BPR_112 vdd_BPR_113 0.694464285714
R555 vdd_BPR_112 vdd_BPR_117 0.907433333333
R556 vdd_BPR_113 vdd_BPR_114 0.722242857143
R557 vdd_BPR_113 vdd_BPR_118 0.837630769231
R558 vdd_BPR_114 vdd_BPR_119 0.837630769231
R559 vdd_BPR_115 vdd_BPR_116 0.722242857143
R560 vdd_BPR_116 vdd_BPR_117 0.694464285714
R561 vdd_BPR_117 vdd_BPR_118 0.694464285714
R562 vdd_BPR_118 vdd_BPR_119 0.722242857143
R563 vdd_BPR_100 vdd_SDCON_17 30
R564 vss_SDCON_0 vss_SDCON_1 14.2045454545
R565 vss_SDCON_0 vss_SDCON_9 10.0961538462
R566 vss_SDCON_1 vss_SDCON_2 14.2045454545
R567 vss_SDCON_1 vss_SDCON_10 10.9375
R568 vss_SDCON_2 vss_SDCON_3 14.7727272727
R569 vss_SDCON_2 vss_SDCON_11 10.0961538462
R570 vss_SDCON_3 vss_SDCON_4 14.2045454545
R571 vss_SDCON_3 vss_SDCON_12 10.0961538462
R572 vss_SDCON_4 vss_SDCON_5 14.2045454545
R573 vss_SDCON_4 vss_SDCON_13 10.9375
R574 vss_SDCON_5 vss_SDCON_6 14.7727272727
R575 vss_SDCON_5 vss_SDCON_14 10.0961538462
R576 vss_SDCON_6 vss_SDCON_7 14.2045454545
R577 vss_SDCON_6 vss_SDCON_15 10.0961538462
R578 vss_SDCON_7 vss_SDCON_8 14.2045454545
R579 vss_SDCON_7 vss_SDCON_16 10.9375
R580 vss_SDCON_8 vss_SDCON_17 10.0961538462
R581 vss_SDCON_9 vss_SDCON_10 15.625
R582 vss_SDCON_9 vss_SDCON_18 10.0961538462
R583 vss_SDCON_10 vss_SDCON_11 15.625
R584 vss_SDCON_10 vss_SDCON_19 10.9375
R585 vss_SDCON_11 vss_SDCON_12 16.25
R586 vss_SDCON_11 vss_SDCON_20 10.0961538462
R587 vss_SDCON_12 vss_SDCON_13 15.625
R588 vss_SDCON_12 vss_SDCON_21 10.0961538462
R589 vss_SDCON_13 vss_SDCON_14 15.625
R590 vss_SDCON_13 vss_SDCON_22 10.9375
R591 vss_SDCON_14 vss_SDCON_15 16.25
R592 vss_SDCON_14 vss_SDCON_23 10.0961538462
R593 vss_SDCON_15 vss_SDCON_16 15.625
R594 vss_SDCON_15 vss_SDCON_24 10.0961538462
R595 vss_SDCON_16 vss_SDCON_17 15.625
R596 vss_SDCON_16 vss_SDCON_25 10.9375
R597 vss_SDCON_17 vss_SDCON_26 10.0961538462
R598 vss_SDCON_18 vss_SDCON_19 14.2045454545
R599 vss_SDCON_19 vss_SDCON_20 14.2045454545
R600 vss_SDCON_20 vss_SDCON_21 14.7727272727
R601 vss_SDCON_21 vss_SDCON_22 14.2045454545
R602 vss_SDCON_22 vss_SDCON_23 14.2045454545
R603 vss_SDCON_23 vss_SDCON_24 14.7727272727
R604 vss_SDCON_24 vss_SDCON_25 14.2045454545
R605 vss_SDCON_25 vss_SDCON_26 14.2045454545
R606 vss_BPR_0 vss_BPR_1 0.722242857143
R607 vss_BPR_0 vss_BPR_5 0.837630769231
R608 vss_BPR_1 vss_BPR_2 0.694464285714
R609 vss_BPR_1 vss_BPR_6 0.837630769231
R610 vss_BPR_2 vss_BPR_3 0.694464285714
R611 vss_BPR_2 vss_BPR_7 0.907433333333
R612 vss_BPR_3 vss_BPR_4 0.722242857143
R613 vss_BPR_3 vss_BPR_8 0.837630769231
R614 vss_BPR_4 vss_BPR_9 0.837630769231
R615 vss_BPR_5 vss_BPR_6 0.722242857143
R616 vss_BPR_5 vss_BPR_10 0.837630769231
R617 vss_BPR_6 vss_BPR_7 0.694464285714
R618 vss_BPR_6 vss_BPR_11 0.837630769231
R619 vss_BPR_7 vss_BPR_8 0.694464285714
R620 vss_BPR_7 vss_BPR_12 0.907433333333
R621 vss_BPR_8 vss_BPR_9 0.722242857143
R622 vss_BPR_8 vss_BPR_13 0.837630769231
R623 vss_BPR_9 vss_BPR_14 0.837630769231
R624 vss_BPR_10 vss_BPR_11 0.722242857143
R625 vss_BPR_10 vss_BPR_15 0.837630769231
R626 vss_BPR_11 vss_BPR_12 0.694464285714
R627 vss_BPR_11 vss_BPR_16 0.837630769231
R628 vss_BPR_12 vss_BPR_13 0.694464285714
R629 vss_BPR_12 vss_BPR_17 0.907433333333
R630 vss_BPR_13 vss_BPR_14 0.722242857143
R631 vss_BPR_13 vss_BPR_18 0.837630769231
R632 vss_BPR_14 vss_BPR_19 0.837630769231
R633 vss_BPR_15 vss_BPR_16 0.722242857143
R634 vss_BPR_15 vss_BPR_20 0.837630769231
R635 vss_BPR_16 vss_BPR_17 0.694464285714
R636 vss_BPR_16 vss_BPR_21 0.837630769231
R637 vss_BPR_17 vss_BPR_18 0.694464285714
R638 vss_BPR_17 vss_BPR_22 0.907433333333
R639 vss_BPR_18 vss_BPR_19 0.722242857143
R640 vss_BPR_18 vss_BPR_23 0.837630769231
R641 vss_BPR_19 vss_BPR_24 0.837630769231
R642 vss_BPR_20 vss_BPR_21 0.722242857143
R643 vss_BPR_20 vss_BPR_25 0.837630769231
R644 vss_BPR_21 vss_BPR_22 0.694464285714
R645 vss_BPR_21 vss_BPR_26 0.837630769231
R646 vss_BPR_22 vss_BPR_23 0.694464285714
R647 vss_BPR_22 vss_BPR_27 0.907433333333
R648 vss_BPR_23 vss_BPR_24 0.722242857143
R649 vss_BPR_23 vss_BPR_28 0.837630769231
R650 vss_BPR_24 vss_BPR_29 0.837630769231
R651 vss_BPR_25 vss_BPR_26 0.722242857143
R652 vss_BPR_25 vss_BPR_30 0.837630769231
R653 vss_BPR_26 vss_BPR_27 0.694464285714
R654 vss_BPR_26 vss_BPR_31 0.837630769231
R655 vss_BPR_27 vss_BPR_28 0.694464285714
R656 vss_BPR_27 vss_BPR_32 0.907433333333
R657 vss_BPR_28 vss_BPR_29 0.722242857143
R658 vss_BPR_28 vss_BPR_33 0.837630769231
R659 vss_BPR_29 vss_BPR_34 0.837630769231
R660 vss_BPR_30 vss_BPR_31 0.722242857143
R661 vss_BPR_30 vss_BPR_35 0.837630769231
R662 vss_BPR_31 vss_BPR_32 0.694464285714
R663 vss_BPR_31 vss_BPR_36 0.837630769231
R664 vss_BPR_32 vss_BPR_33 0.694464285714
R665 vss_BPR_32 vss_BPR_37 0.907433333333
R666 vss_BPR_33 vss_BPR_34 0.722242857143
R667 vss_BPR_33 vss_BPR_38 0.837630769231
R668 vss_BPR_34 vss_BPR_39 0.837630769231
R669 vss_BPR_35 vss_BPR_36 0.722242857143
R670 vss_BPR_35 vss_BPR_40 0.837630769231
R671 vss_BPR_36 vss_BPR_37 0.694464285714
R672 vss_BPR_36 vss_BPR_41 0.837630769231
R673 vss_BPR_37 vss_BPR_38 0.694464285714
R674 vss_BPR_37 vss_BPR_42 0.907433333333
R675 vss_BPR_38 vss_BPR_39 0.722242857143
R676 vss_BPR_38 vss_BPR_43 0.837630769231
R677 vss_BPR_39 vss_BPR_44 0.837630769231
R678 vss_BPR_40 vss_BPR_41 0.722242857143
R679 vss_BPR_40 vss_BPR_45 0.837630769231
R680 vss_BPR_41 vss_BPR_42 0.694464285714
R681 vss_BPR_41 vss_BPR_46 0.837630769231
R682 vss_BPR_42 vss_BPR_43 0.694464285714
R683 vss_BPR_42 vss_BPR_47 0.907433333333
R684 vss_BPR_43 vss_BPR_44 0.722242857143
R685 vss_BPR_43 vss_BPR_48 0.837630769231
R686 vss_BPR_44 vss_BPR_49 0.837630769231
R687 vss_BPR_45 vss_BPR_46 0.722242857143
R688 vss_BPR_45 vss_BPR_50 0.837630769231
R689 vss_BPR_46 vss_BPR_47 0.694464285714
R690 vss_BPR_46 vss_BPR_51 0.837630769231
R691 vss_BPR_47 vss_BPR_48 0.694464285714
R692 vss_BPR_47 vss_BPR_52 0.907433333333
R693 vss_BPR_48 vss_BPR_49 0.722242857143
R694 vss_BPR_48 vss_BPR_53 0.837630769231
R695 vss_BPR_49 vss_BPR_54 0.837630769231
R696 vss_BPR_50 vss_BPR_51 0.722242857143
R697 vss_BPR_50 vss_BPR_55 0.837630769231
R698 vss_BPR_51 vss_BPR_52 0.694464285714
R699 vss_BPR_51 vss_BPR_56 0.837630769231
R700 vss_BPR_52 vss_BPR_53 0.694464285714
R701 vss_BPR_52 vss 0.907433333333
R702 vss_BPR_53 vss_BPR_54 0.722242857143
R703 vss_BPR_53 vss_BPR_58 0.837630769231
R704 vss_BPR_54 vss_BPR_59 0.837630769231
R705 vss_BPR_55 vss_BPR_56 0.722242857143
R706 vss_BPR_55 vss_BPR_60 0.837630769231
R707 vss_BPR_56 vss 0.694464285714
R708 vss_BPR_56 vss_BPR_61 0.837630769231
R709 vss vss_BPR_58 0.694464285714
R710 vss vss_BPR_62 0.907433333333
R711 vss_BPR_58 vss_BPR_59 0.722242857143
R712 vss_BPR_58 vss_BPR_63 0.837630769231
R713 vss_BPR_59 vss_BPR_64 0.837630769231
R714 vss_BPR_60 vss_BPR_61 0.722242857143
R715 vss_BPR_60 vss_BPR_65 0.837630769231
R716 vss_BPR_61 vss_BPR_62 0.694464285714
R717 vss_BPR_61 vss_BPR_66 0.837630769231
R718 vss_BPR_62 vss_BPR_63 0.694464285714
R719 vss_BPR_62 vss_BPR_67 0.907433333333
R720 vss_BPR_63 vss_BPR_64 0.722242857143
R721 vss_BPR_63 vss_BPR_68 0.837630769231
R722 vss_BPR_64 vss_BPR_69 0.837630769231
R723 vss_BPR_65 vss_BPR_66 0.722242857143
R724 vss_BPR_65 vss_BPR_70 0.837630769231
R725 vss_BPR_66 vss_BPR_67 0.694464285714
R726 vss_BPR_66 vss_BPR_71 0.837630769231
R727 vss_BPR_67 vss_BPR_68 0.694464285714
R728 vss_BPR_67 vss_BPR_72 0.907433333333
R729 vss_BPR_68 vss_BPR_69 0.722242857143
R730 vss_BPR_68 vss_BPR_73 0.837630769231
R731 vss_BPR_69 vss_BPR_74 0.837630769231
R732 vss_BPR_70 vss_BPR_71 0.722242857143
R733 vss_BPR_70 vss_BPR_75 0.837630769231
R734 vss_BPR_71 vss_BPR_72 0.694464285714
R735 vss_BPR_71 vss_BPR_76 0.837630769231
R736 vss_BPR_72 vss_BPR_73 0.694464285714
R737 vss_BPR_72 vss_BPR_77 0.907433333333
R738 vss_BPR_73 vss_BPR_74 0.722242857143
R739 vss_BPR_73 vss_BPR_78 0.837630769231
R740 vss_BPR_74 vss_BPR_79 0.837630769231
R741 vss_BPR_75 vss_BPR_76 0.722242857143
R742 vss_BPR_75 vss_BPR_80 0.837630769231
R743 vss_BPR_76 vss_BPR_77 0.694464285714
R744 vss_BPR_76 vss_BPR_81 0.837630769231
R745 vss_BPR_77 vss_BPR_78 0.694464285714
R746 vss_BPR_77 vss_BPR_82 0.907433333333
R747 vss_BPR_78 vss_BPR_79 0.722242857143
R748 vss_BPR_78 vss_BPR_83 0.837630769231
R749 vss_BPR_79 vss_BPR_84 0.837630769231
R750 vss_BPR_80 vss_BPR_81 0.722242857143
R751 vss_BPR_80 vss_BPR_85 0.837630769231
R752 vss_BPR_81 vss_BPR_82 0.694464285714
R753 vss_BPR_81 vss_BPR_86 0.837630769231
R754 vss_BPR_82 vss_BPR_83 0.694464285714
R755 vss_BPR_82 vss_BPR_87 0.907433333333
R756 vss_BPR_83 vss_BPR_84 0.722242857143
R757 vss_BPR_83 vss_BPR_88 0.837630769231
R758 vss_BPR_84 vss_BPR_89 0.837630769231
R759 vss_BPR_85 vss_BPR_86 0.722242857143
R760 vss_BPR_85 vss_BPR_90 0.837630769231
R761 vss_BPR_86 vss_BPR_87 0.694464285714
R762 vss_BPR_86 vss_BPR_91 0.837630769231
R763 vss_BPR_87 vss_BPR_88 0.694464285714
R764 vss_BPR_87 vss_BPR_92 0.907433333333
R765 vss_BPR_88 vss_BPR_89 0.722242857143
R766 vss_BPR_88 vss_BPR_93 0.837630769231
R767 vss_BPR_89 vss_BPR_94 0.837630769231
R768 vss_BPR_90 vss_BPR_91 0.722242857143
R769 vss_BPR_90 vss_BPR_95 0.837630769231
R770 vss_BPR_91 vss_BPR_92 0.694464285714
R771 vss_BPR_91 vss_BPR_96 0.837630769231
R772 vss_BPR_92 vss_BPR_93 0.694464285714
R773 vss_BPR_92 vss_BPR_97 0.907433333333
R774 vss_BPR_93 vss_BPR_94 0.722242857143
R775 vss_BPR_93 vss_BPR_98 0.837630769231
R776 vss_BPR_94 vss_BPR_99 0.837630769231
R777 vss_BPR_95 vss_BPR_96 0.722242857143
R778 vss_BPR_95 vss_BPR_100 0.837630769231
R779 vss_BPR_96 vss_BPR_97 0.694464285714
R780 vss_BPR_96 vss_BPR_101 0.837630769231
R781 vss_BPR_97 vss_BPR_98 0.694464285714
R782 vss_BPR_97 vss_BPR_102 0.907433333333
R783 vss_BPR_98 vss_BPR_99 0.722242857143
R784 vss_BPR_98 vss_BPR_103 0.837630769231
R785 vss_BPR_99 vss_BPR_104 0.837630769231
R786 vss_BPR_100 vss_BPR_101 0.722242857143
R787 vss_BPR_100 vss_BPR_105 0.837630769231
R788 vss_BPR_101 vss_BPR_102 0.694464285714
R789 vss_BPR_101 vss_BPR_106 0.837630769231
R790 vss_BPR_102 vss_BPR_103 0.694464285714
R791 vss_BPR_102 vss_BPR_107 0.907433333333
R792 vss_BPR_103 vss_BPR_104 0.722242857143
R793 vss_BPR_103 vss_BPR_108 0.837630769231
R794 vss_BPR_104 vss_BPR_109 0.837630769231
R795 vss_BPR_105 vss_BPR_106 0.722242857143
R796 vss_BPR_105 vss_BPR_110 0.837630769231
R797 vss_BPR_106 vss_BPR_107 0.694464285714
R798 vss_BPR_106 vss_BPR_111 0.837630769231
R799 vss_BPR_107 vss_BPR_108 0.694464285714
R800 vss_BPR_107 vss_BPR_112 0.907433333333
R801 vss_BPR_108 vss_BPR_109 0.722242857143
R802 vss_BPR_108 vss_BPR_113 0.837630769231
R803 vss_BPR_109 vss_BPR_114 0.837630769231
R804 vss_BPR_110 vss_BPR_111 0.722242857143
R805 vss_BPR_110 vss_BPR_115 0.837630769231
R806 vss_BPR_111 vss_BPR_112 0.694464285714
R807 vss_BPR_111 vss_BPR_116 0.837630769231
R808 vss_BPR_112 vss_BPR_113 0.694464285714
R809 vss_BPR_112 vss_BPR_117 0.907433333333
R810 vss_BPR_113 vss_BPR_114 0.722242857143
R811 vss_BPR_113 vss_BPR_118 0.837630769231
R812 vss_BPR_114 vss_BPR_119 0.837630769231
R813 vss_BPR_115 vss_BPR_116 0.722242857143
R814 vss_BPR_116 vss_BPR_117 0.694464285714
R815 vss_BPR_117 vss_BPR_118 0.694464285714
R816 vss_BPR_118 vss_BPR_119 0.722242857143
R817 vss_BPR_14 vss_SDCON_9 30
C0_1 net12_M1_10 net7_M1_10 1.05485e-17
C0_2 net12_M1_10 vdd 2.98865e-18
C0_3 net12_M1_10 vss 2.22678e-18
C0_ref net12_M1_10 vss 4.77677e-18
C1_2 net7_M1_10 vdd 2.22576e-18
C1_3 net7_M1_10 vss 2.98821e-18
C1_ref net7_M1_10 vss 4.79923e-18
C2_3 vdd vss 9.91495e-18
C2_ref vdd vss 1.705454e-17
.ENDS decap_rc

XI ideal_vdd 0 decap_ideal
XR rc_vdd 0 decap_rc
VIDEAL ideal_vdd 0 DC 0.9 AC 1
VRC rc_vdd 0 DC 0.9 AC 1
.OPTIONS DEVICE TEMP=25 GMIN=1e-15
.OPTIONS NONLIN ABSTOL=1e-15 RELTOL=1e-8 RHSTOL=1e-14
.OP
.AC DEC 10 1e6 1e12
.PRINT AC FORMAT=CSV PRECISION=15 IR(VIDEAL) II(VIDEAL) IR(VRC) II(VRC)
.PRINT AC_IC FORMAT=CSV PRECISION=15 I(VIDEAL) I(VRC) V(XI:net7) V(XI:net12)
.END
