.subckt gt2_6t_decapcc_cp_w31_ulvt vdd vss
*.PININFO vdd:B vss:B
MM1 net7 net12 vss vss nmos_ulvt W=0.031u L=0.014u M=1
MM0 net12 net7 vdd vdd pmos_ulvt W=0.031u L=0.014u M=1
.ends gt2_6t_decapcc_cp_w31_ulvt

.subckt gt2_6t_inv_x1_w31_ulvt A Y vdd vss
*.PININFO A:I Y:O vdd:B vss:B
MM0 Y A vdd vdd pmos_ulvt W=0.031u L=0.014u M=1
MM1 Y A vss vss nmos_ulvt W=0.031u L=0.014u M=1
.ends gt2_6t_inv_x1_w31_ulvt

.SUBCKT decapcc_mixed_ulvt A_0_0 Y_0_0 A_2_0 Y_2_0 A_0_1 Y_0_1 A_2_1 Y_2_1 A_0_2 Y_0_2 A_2_2 Y_2_2 vdd vss
X00 A_0_0 Y_0_0 vdd vss gt2_6t_inv_x1_w31_ulvt
X10  vdd vss gt2_6t_decapcc_cp_w31_ulvt
X20 A_2_0 Y_2_0 vdd vss gt2_6t_inv_x1_w31_ulvt
X01 A_0_1 Y_0_1 vdd vss gt2_6t_inv_x1_w31_ulvt
X11  vdd vss gt2_6t_decapcc_cp_w31_ulvt
X21 A_2_1 Y_2_1 vdd vss gt2_6t_inv_x1_w31_ulvt
X02 A_0_2 Y_0_2 vdd vss gt2_6t_inv_x1_w31_ulvt
X12  vdd vss gt2_6t_decapcc_cp_w31_ulvt
X22 A_2_2 Y_2_2 vdd vss gt2_6t_inv_x1_w31_ulvt
.ENDS decapcc_mixed_ulvt
