* GT2N extracted

.SUBCKT decapcc_abutment_ulvt vdd vss
X$1 vss vdd gt2_6t_decapcc_cp_w31_ulvt
X$2 vss vdd gt2_6t_decapcc_cp_w31_ulvt
X$3 vss vdd gt2_6t_decapcc_cp_w31_ulvt
X$4 vss vdd gt2_6t_decapcc_cp_w31_ulvt
X$5 vss vdd gt2_6t_decapcc_cp_w31_ulvt
X$6 vss vdd gt2_6t_decapcc_cp_w31_ulvt
X$7 vss vdd gt2_6t_decapcc_cp_w31_ulvt
X$8 vss vdd gt2_6t_decapcc_cp_w31_ulvt
X$9 vss vdd gt2_6t_decapcc_cp_w31_ulvt
.ENDS decapcc_abutment_ulvt

.SUBCKT gt2_6t_decapcc_cp_w31_ulvt vss vdd
M$1 \$3 \$4 vss vss nmos_ulvt L=0.014U W=0.031U AS=0.000868P AD=0.000868P
+ PS=0.118U PD=0.118U
M$2 vdd \$3 \$4 vdd pmos_ulvt L=0.014U W=0.031U AS=0.000868P AD=0.000868P
+ PS=0.118U PD=0.118U
.ENDS gt2_6t_decapcc_cp_w31_ulvt
