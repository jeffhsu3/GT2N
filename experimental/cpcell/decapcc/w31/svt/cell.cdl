.SUBCKT gt2_6t_decapcc_cp_w31_svt vdd vss
MM1 net7 net12 vss vss nmos_svt W=0.031u L=0.014u M=1
MM0 net12 net7 vdd vdd pmos_svt W=0.031u L=0.014u M=1
.ENDS gt2_6t_decapcc_cp_w31_svt
