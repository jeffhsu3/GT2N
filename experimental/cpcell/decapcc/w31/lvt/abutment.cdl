.subckt gt2_6t_decapcc_cp_w31_lvt vdd vss
*.PININFO vdd:B vss:B
MM1 net7 net12 vss vss nmos_lvt W=0.031u L=0.014u M=1
MM0 net12 net7 vdd vdd pmos_lvt W=0.031u L=0.014u M=1
.ends gt2_6t_decapcc_cp_w31_lvt

.SUBCKT decapcc_abutment_lvt  vdd vss
X00  vdd vss gt2_6t_decapcc_cp_w31_lvt
X10  vdd vss gt2_6t_decapcc_cp_w31_lvt
X20  vdd vss gt2_6t_decapcc_cp_w31_lvt
X01  vdd vss gt2_6t_decapcc_cp_w31_lvt
X11  vdd vss gt2_6t_decapcc_cp_w31_lvt
X21  vdd vss gt2_6t_decapcc_cp_w31_lvt
X02  vdd vss gt2_6t_decapcc_cp_w31_lvt
X12  vdd vss gt2_6t_decapcc_cp_w31_lvt
X22  vdd vss gt2_6t_decapcc_cp_w31_lvt
.ENDS decapcc_abutment_lvt
