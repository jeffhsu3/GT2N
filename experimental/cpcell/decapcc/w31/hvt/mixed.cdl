.subckt gt2_6t_decapcc_cp_w31_hvt vdd vss
*.PININFO vdd:B vss:B
MM1 net7 net12 vss vss nmos_hvt W=0.031u L=0.014u M=1
MM0 net12 net7 vdd vdd pmos_hvt W=0.031u L=0.014u M=1
.ends gt2_6t_decapcc_cp_w31_hvt

.subckt gt2_6t_inv_x1_w31_hvt A Y vdd vss
*.PININFO A:I Y:O vdd:B vss:B
MM0 Y A vdd vdd pmos_hvt W=0.031u L=0.014u M=1
MM1 Y A vss vss nmos_hvt W=0.031u L=0.014u M=1
.ends gt2_6t_inv_x1_w31_hvt

.SUBCKT decapcc_mixed_hvt A_0_0 Y_0_0 A_2_0 Y_2_0 A_0_1 Y_0_1 A_2_1 Y_2_1 A_0_2 Y_0_2 A_2_2 Y_2_2 vdd vss
X00 A_0_0 Y_0_0 vdd vss gt2_6t_inv_x1_w31_hvt
X10  vdd vss gt2_6t_decapcc_cp_w31_hvt
X20 A_2_0 Y_2_0 vdd vss gt2_6t_inv_x1_w31_hvt
X01 A_0_1 Y_0_1 vdd vss gt2_6t_inv_x1_w31_hvt
X11  vdd vss gt2_6t_decapcc_cp_w31_hvt
X21 A_2_1 Y_2_1 vdd vss gt2_6t_inv_x1_w31_hvt
X02 A_0_2 Y_0_2 vdd vss gt2_6t_inv_x1_w31_hvt
X12  vdd vss gt2_6t_decapcc_cp_w31_hvt
X22 A_2_2 Y_2_2 vdd vss gt2_6t_inv_x1_w31_hvt
.ENDS decapcc_mixed_hvt
