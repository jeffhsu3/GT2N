* GT2N extracted

.SUBCKT decapcc_abutment_hvt vdd vss
X$1 vss vdd gt2_6t_decapcc_cp_w31_hvt
X$2 vss vdd gt2_6t_decapcc_cp_w31_hvt
X$3 vss vdd gt2_6t_decapcc_cp_w31_hvt
X$4 vss vdd gt2_6t_decapcc_cp_w31_hvt
X$5 vss vdd gt2_6t_decapcc_cp_w31_hvt
X$6 vss vdd gt2_6t_decapcc_cp_w31_hvt
X$7 vss vdd gt2_6t_decapcc_cp_w31_hvt
X$8 vss vdd gt2_6t_decapcc_cp_w31_hvt
X$9 vss vdd gt2_6t_decapcc_cp_w31_hvt
.ENDS decapcc_abutment_hvt

.SUBCKT gt2_6t_decapcc_cp_w31_hvt vss vdd
M$1 \$3 \$4 vss vss nmos_hvt L=0.014U W=0.031U AS=0.000868P AD=0.000868P
+ PS=0.118U PD=0.118U
M$2 vdd \$3 \$4 vdd pmos_hvt L=0.014U W=0.031U AS=0.000868P AD=0.000868P
+ PS=0.118U PD=0.118U
.ENDS gt2_6t_decapcc_cp_w31_hvt
