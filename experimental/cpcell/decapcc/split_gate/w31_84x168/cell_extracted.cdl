* GT2N extracted

.SUBCKT gt2n_split_decap_w31_h168_lvt vss vdd
M$1 \$3 \$4 vss vss nmos_lvt L=0.014U W=0.031U AS=0.000868P AD=0.000868P
+ PS=0.118U PD=0.118U
M$2 \$4 \$3 vdd vdd pmos_lvt L=0.014U W=0.031U AS=0.000868P AD=0.000868P
+ PS=0.118U PD=0.118U
.ENDS gt2n_split_decap_w31_h168_lvt
