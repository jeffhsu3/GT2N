GT2N decap extracted capacitance and model leakage
.INCLUDE "/home/jeff/iv4/repos/GT2N/experimental/cpcell/decapcc/split_gate/w31_126x144/electrical/lvt_sweep/models_lvt.inc"
* Partial PEX: 3D M0/V0/M1/BPR Maxwell capacitance; GT2 dielectric interfaces; GATE/SDCON/BPR/M0/M1 sheet and VG/VSD/V0/VBPR contact resistance. BSIM-CMG supplies intrinsic/overlap/fringe device C. Additional FEOL, VG/VSD/VBPR C, diffusion spreading R, neighboring cells, and chip/package environment are not extracted. Far-field reference is tied to vss.
.SUBCKT decap_ideal vdd vss
M1 net7 net12 vss vss nmos_lvt L=0.014u
M2 vdd net7 net12 vdd pmos_lvt L=0.014u
.ENDS decap_ideal

* Partial PEX: 3D M0/V0/M1/BPR Maxwell capacitance; GT2 dielectric interfaces; GATE/SDCON/BPR/M0/M1 sheet and VG/VSD/V0/VBPR contact resistance. BSIM-CMG supplies intrinsic/overlap/fringe device C. Additional FEOL, VG/VSD/VBPR C, diffusion spreading R, neighboring cells, and chip/package environment are not extracted. Far-field reference is tied to vss.
.SUBCKT decap_rc vdd vss
M1 net7_SDCON_8 net12_GATE_16 vss_SDCON_14 vss nmos_lvt L=0.014u
M2 vdd_SDCON_39 net7_GATE_16 net12_SDCON_8 vdd pmos_lvt L=0.014u
R0 net12_GATE_0 net12_GATE_1 6.9565
R1 net12_GATE_0 net12_GATE_11 6.9565
R2 net12_GATE_1 net12_GATE_2 6.9565
R3 net12_GATE_1 net12_GATE_12 6.9565
R4 net12_GATE_2 net12_GATE_3 6.9565
R5 net12_GATE_2 net12_GATE_13 6.9565
R6 net12_GATE_3 net12_GATE_4 6.9565
R7 net12_GATE_3 net12_GATE_14 6.9565
R8 net12_GATE_4 net12_GATE_5 6.9565
R9 net12_GATE_4 net12_GATE_15 6.9565
R10 net12_GATE_5 net12_GATE_6 6.9565
R11 net12_GATE_5 net12_GATE_16 6.9565
R12 net12_GATE_6 net12_GATE_7 6.9565
R13 net12_GATE_6 net12_GATE_17 6.9565
R14 net12_GATE_7 net12_GATE_8 6.9565
R15 net12_GATE_7 net12_GATE_18 6.9565
R16 net12_GATE_8 net12_GATE_9 6.9565
R17 net12_GATE_8 net12_GATE_19 6.9565
R18 net12_GATE_9 net12_GATE_10 6.9565
R19 net12_GATE_9 net12_GATE_20 6.9565
R20 net12_GATE_10 net12_GATE_21 6.9565
R21 net12_GATE_11 net12_GATE_12 6.9565
R22 net12_GATE_12 net12_GATE_13 6.9565
R23 net12_GATE_13 net12_GATE_14 6.9565
R24 net12_GATE_14 net12_GATE_15 6.9565
R25 net12_GATE_15 net12_GATE_16 6.9565
R26 net12_GATE_16 net12_GATE_17 6.9565
R27 net12_GATE_17 net12_GATE_18 6.9565
R28 net12_GATE_18 net12_GATE_19 6.9565
R29 net12_GATE_19 net12_GATE_20 6.9565
R30 net12_GATE_20 net12_GATE_21 6.9565
R31 net12_SDCON_0 net12_SDCON_1 15.3409090909
R32 net12_SDCON_0 net12_SDCON_6 9.375
R33 net12_SDCON_1 net12_SDCON_2 15.3409090909
R34 net12_SDCON_1 net12_SDCON_7 10.0961538462
R35 net12_SDCON_2 net12_SDCON_3 15.9090909091
R36 net12_SDCON_2 net12_SDCON_8 9.375
R37 net12_SDCON_3 net12_SDCON_4 15.3409090909
R38 net12_SDCON_3 net12_SDCON_9 9.375
R39 net12_SDCON_4 net12_SDCON_5 15.3409090909
R40 net12_SDCON_4 net12_SDCON_10 10.0961538462
R41 net12_SDCON_5 net12_SDCON_11 9.375
R42 net12_SDCON_6 net12_SDCON_7 16.875
R43 net12_SDCON_6 net12_SDCON_12 9.375
R44 net12_SDCON_7 net12_SDCON_8 16.875
R45 net12_SDCON_7 net12_SDCON_13 10.0961538462
R46 net12_SDCON_8 net12_SDCON_9 17.5
R47 net12_SDCON_8 net12_SDCON_14 9.375
R48 net12_SDCON_9 net12_SDCON_10 16.875
R49 net12_SDCON_9 net12_SDCON_15 9.375
R50 net12_SDCON_10 net12_SDCON_11 16.875
R51 net12_SDCON_10 net12_SDCON_16 10.0961538462
R52 net12_SDCON_11 net12_SDCON_17 9.375
R53 net12_SDCON_12 net12_SDCON_13 15.3409090909
R54 net12_SDCON_13 net12_SDCON_14 15.3409090909
R55 net12_SDCON_14 net12_SDCON_15 15.9090909091
R56 net12_SDCON_15 net12_SDCON_16 15.3409090909
R57 net12_SDCON_16 net12_SDCON_17 15.3409090909
R58 net12_M0_0 net12_M0_1 6.88707692308
R59 net12_M0_0 net12_M0_2 8.08275
R60 net12_M0_1 net12_M0_3 8.08275
R61 net12_M0_2 net12_M0_3 6.88707692308
R62 net12_M0_2 net12_M0_4 8.08275
R63 net12_M0_3 net12_M0_5 8.08275
R64 net12_M0_4 net12_M0_5 6.88707692308
R65 net12_M0_4 net12_M0_6 7.771875
R66 net12_M0_5 net12_M0_7 7.771875
R67 net12_M0_6 net12_M0_7 7.461
R68 net12_M0_6 net12_M0_8 7.771875
R69 net12_M0_7 net12_M0_9 7.771875
R70 net12_M0_8 net12_M0_9 6.88707692308
R71 net12_M0_8 net12_M0_10 8.08275
R72 net12_M0_9 net12_M0_11 8.08275
R73 net12_M0_10 net12_M0_11 6.88707692308
R74 net12_M0_10 net12_M0_12 8.08275
R75 net12_M0_11 net12_M0_13 8.08275
R76 net12_M0_12 net12_M0_13 6.88707692308
R77 net12_M0_14 net12_M0_15 6.88707692308
R78 net12_M0_14 net12_M0_16 8.08275
R79 net12_M0_15 net12_M0_17 8.08275
R80 net12_M0_16 net12_M0_17 6.88707692308
R81 net12_M0_16 net12_M0_18 8.393625
R82 net12_M0_17 net12_M0_19 8.393625
R83 net12_M0_18 net12_M0_19 6.39514285714
R84 net12_M0_18 net12_M0_20 8.393625
R85 net12_M0_19 net12_M0_21 8.393625
R86 net12_M0_20 net12_M0_21 6.88707692308
R87 net12_M0_20 net12_M0_22 8.08275
R88 net12_M0_21 net12_M0_23 8.08275
R89 net12_M0_22 net12_M0_23 6.88707692308
R90 net12_M0_22 net12_M0_24 8.08275
R91 net12_M0_23 net12_M0_25 8.08275
R92 net12_M0_24 net12_M0_25 6.88707692308
R93 net12_M0_24 net12_M0_26 8.08275
R94 net12_M0_25 net12_M0_27 8.08275
R95 net12_M0_26 net12_M0_27 6.88707692308
R96 net12_M0_26 net12_M0_28 8.393625
R97 net12_M0_27 net12_M0_29 8.393625
R98 net12_M0_28 net12_M0_29 6.39514285714
R99 net12_M0_28 net12_M0_30 8.393625
R100 net12_M0_29 net12_M0_31 8.393625
R101 net12_M0_30 net12_M0_31 6.88707692308
R102 net12_M0_30 net12_M0_32 8.08275
R103 net12_M0_31 net12_M0_33 8.08275
R104 net12_M0_32 net12_M0_33 6.88707692308
R105 net12_M1_0 net12_M1_1 5.46875
R106 net12_M1_0 net12_M1_7 6.59615384615
R107 net12_M1_1 net12_M1_2 5.46875
R108 net12_M1_1 net12_M1_8 7.14583333333
R109 net12_M1_2 net12_M1_3 5.46875
R110 net12_M1_2 net12_M1_9 6.59615384615
R111 net12_M1_3 net12_M1_4 5.46875
R112 net12_M1_3 net12_M1_10 7.14583333333
R113 net12_M1_4 net12_M1_5 5.46875
R114 net12_M1_4 net12_M1_11 6.59615384615
R115 net12_M1_5 net12_M1_6 5.46875
R116 net12_M1_5 net12_M1_12 7.14583333333
R117 net12_M1_6 net12_M1_13 6.59615384615
R118 net12_M1_7 net12_M1_8 5.46875
R119 net12_M1_8 net12_M1_9 5.46875
R120 net12_M1_9 net12_M1_10 5.46875
R121 net12_M1_10 net12_M1_11 5.46875
R122 net12_M1_11 net12_M1_12 5.46875
R123 net12_M1_12 net12_M1_13 5.46875
R124 net12_GATE_20 net12_M0_10 34.2214285714
R125 net12_SDCON_8 net12_M0_30 36.86
R126 net12_M0_2 net12_M1_1 54.99
R127 net12_M0_16 net12_M1_12 54.99
R128 net7_GATE_0 net7_GATE_1 6.9565
R129 net7_GATE_0 net7_GATE_11 6.9565
R130 net7_GATE_1 net7_GATE_2 6.9565
R131 net7_GATE_1 net7_GATE_12 6.9565
R132 net7_GATE_2 net7_GATE_3 6.9565
R133 net7_GATE_2 net7_GATE_13 6.9565
R134 net7_GATE_3 net7_GATE_4 6.9565
R135 net7_GATE_3 net7_GATE_14 6.9565
R136 net7_GATE_4 net7_GATE_5 6.9565
R137 net7_GATE_4 net7_GATE_15 6.9565
R138 net7_GATE_5 net7_GATE_6 6.9565
R139 net7_GATE_5 net7_GATE_16 6.9565
R140 net7_GATE_6 net7_GATE_7 6.9565
R141 net7_GATE_6 net7_GATE_17 6.9565
R142 net7_GATE_7 net7_GATE_8 6.9565
R143 net7_GATE_7 net7_GATE_18 6.9565
R144 net7_GATE_8 net7_GATE_9 6.9565
R145 net7_GATE_8 net7_GATE_19 6.9565
R146 net7_GATE_9 net7_GATE_10 6.9565
R147 net7_GATE_9 net7_GATE_20 6.9565
R148 net7_GATE_10 net7_GATE_21 6.9565
R149 net7_GATE_11 net7_GATE_12 6.9565
R150 net7_GATE_12 net7_GATE_13 6.9565
R151 net7_GATE_13 net7_GATE_14 6.9565
R152 net7_GATE_14 net7_GATE_15 6.9565
R153 net7_GATE_15 net7_GATE_16 6.9565
R154 net7_GATE_16 net7_GATE_17 6.9565
R155 net7_GATE_17 net7_GATE_18 6.9565
R156 net7_GATE_18 net7_GATE_19 6.9565
R157 net7_GATE_19 net7_GATE_20 6.9565
R158 net7_GATE_20 net7_GATE_21 6.9565
R159 net7_SDCON_0 net7_SDCON_1 15.3409090909
R160 net7_SDCON_0 net7_SDCON_6 9.375
R161 net7_SDCON_1 net7_SDCON_2 15.3409090909
R162 net7_SDCON_1 net7_SDCON_7 10.0961538462
R163 net7_SDCON_2 net7_SDCON_3 15.9090909091
R164 net7_SDCON_2 net7_SDCON_8 9.375
R165 net7_SDCON_3 net7_SDCON_4 15.3409090909
R166 net7_SDCON_3 net7_SDCON_9 9.375
R167 net7_SDCON_4 net7_SDCON_5 15.3409090909
R168 net7_SDCON_4 net7_SDCON_10 10.0961538462
R169 net7_SDCON_5 net7_SDCON_11 9.375
R170 net7_SDCON_6 net7_SDCON_7 16.875
R171 net7_SDCON_6 net7_SDCON_12 9.375
R172 net7_SDCON_7 net7_SDCON_8 16.875
R173 net7_SDCON_7 net7_SDCON_13 10.0961538462
R174 net7_SDCON_8 net7_SDCON_9 17.5
R175 net7_SDCON_8 net7_SDCON_14 9.375
R176 net7_SDCON_9 net7_SDCON_10 16.875
R177 net7_SDCON_9 net7_SDCON_15 9.375
R178 net7_SDCON_10 net7_SDCON_11 16.875
R179 net7_SDCON_10 net7_SDCON_16 10.0961538462
R180 net7_SDCON_11 net7_SDCON_17 9.375
R181 net7_SDCON_12 net7_SDCON_13 15.3409090909
R182 net7_SDCON_13 net7_SDCON_14 15.3409090909
R183 net7_SDCON_14 net7_SDCON_15 15.9090909091
R184 net7_SDCON_15 net7_SDCON_16 15.3409090909
R185 net7_SDCON_16 net7_SDCON_17 15.3409090909
R186 net7_M0_0 net7_M0_1 6.88707692308
R187 net7_M0_0 net7_M0_2 8.08275
R188 net7_M0_1 net7_M0_3 8.08275
R189 net7_M0_2 net7_M0_3 6.88707692308
R190 net7_M0_2 net7_M0_4 8.393625
R191 net7_M0_3 net7_M0_5 8.393625
R192 net7_M0_4 net7_M0_5 6.39514285714
R193 net7_M0_4 net7_M0_6 8.393625
R194 net7_M0_5 net7_M0_7 8.393625
R195 net7_M0_6 net7_M0_7 6.88707692308
R196 net7_M0_6 net7_M0_8 8.08275
R197 net7_M0_7 net7_M0_9 8.08275
R198 net7_M0_8 net7_M0_9 6.88707692308
R199 net7_M0_8 net7_M0_10 8.08275
R200 net7_M0_9 net7_M0_11 8.08275
R201 net7_M0_10 net7_M0_11 6.88707692308
R202 net7_M0_10 net7_M0_12 8.08275
R203 net7_M0_11 net7_M0_13 8.08275
R204 net7_M0_12 net7_M0_13 6.88707692308
R205 net7_M0_12 net7_M0_14 8.393625
R206 net7_M0_13 net7_M0_15 8.393625
R207 net7_M0_14 net7_M0_15 6.39514285714
R208 net7_M0_14 net7_M0_16 8.393625
R209 net7_M0_15 net7_M0_17 8.393625
R210 net7_M0_16 net7_M0_17 6.88707692308
R211 net7_M0_16 net7_M0_18 8.08275
R212 net7_M0_17 net7_M0_19 8.08275
R213 net7_M0_18 net7_M0_19 6.88707692308
R214 net7_M0_20 net7_M0_21 6.88707692308
R215 net7_M0_20 net7_M0_22 8.08275
R216 net7_M0_21 net7_M0_23 8.08275
R217 net7_M0_22 net7_M0_23 6.88707692308
R218 net7_M0_22 net7_M0_24 8.08275
R219 net7_M0_23 net7_M0_25 8.08275
R220 net7_M0_24 net7_M0_25 6.88707692308
R221 net7_M0_24 net7_M0_26 7.771875
R222 net7_M0_25 net7_M0_27 7.771875
R223 net7_M0_26 net7_M0_27 7.461
R224 net7_M0_26 net7_M0_28 7.771875
R225 net7_M0_27 net7_M0_29 7.771875
R226 net7_M0_28 net7_M0_29 6.88707692308
R227 net7_M0_28 net7_M0_30 8.08275
R228 net7_M0_29 net7_M0_31 8.08275
R229 net7_M0_30 net7_M0_31 6.88707692308
R230 net7_M0_30 net7_M0_32 8.08275
R231 net7_M0_31 net7_M0_33 8.08275
R232 net7_M0_32 net7_M0_33 6.88707692308
R233 net7_M1_0 net7_M1_1 5.46875
R234 net7_M1_0 net7_M1_7 6.59615384615
R235 net7_M1_1 net7_M1_2 5.46875
R236 net7_M1_1 net7_M1_8 7.14583333333
R237 net7_M1_2 net7_M1_3 5.46875
R238 net7_M1_2 net7_M1_9 6.59615384615
R239 net7_M1_3 net7_M1_4 5.46875
R240 net7_M1_3 net7_M1_10 7.14583333333
R241 net7_M1_4 net7_M1_5 5.46875
R242 net7_M1_4 net7_M1_11 6.59615384615
R243 net7_M1_5 net7_M1_6 5.46875
R244 net7_M1_5 net7_M1_12 7.14583333333
R245 net7_M1_6 net7_M1_13 6.59615384615
R246 net7_M1_7 net7_M1_8 5.46875
R247 net7_M1_8 net7_M1_9 5.46875
R248 net7_M1_9 net7_M1_10 5.46875
R249 net7_M1_10 net7_M1_11 5.46875
R250 net7_M1_11 net7_M1_12 5.46875
R251 net7_M1_12 net7_M1_13 5.46875
R252 net7_GATE_1 net7_M0_22 34.2214285714
R253 net7_SDCON_9 net7_M0_2 36.86
R254 net7_M0_16 net7_M1_1 54.99
R255 net7_M0_30 net7_M1_12 54.99
R256 vdd_SDCON_0 vdd_SDCON_1 14.2045454545
R257 vdd_SDCON_0 vdd_SDCON_9 10.0961538462
R258 vdd_SDCON_1 vdd_SDCON_2 14.2045454545
R259 vdd_SDCON_1 vdd_SDCON_10 10.9375
R260 vdd_SDCON_2 vdd_SDCON_3 14.7727272727
R261 vdd_SDCON_2 vdd_SDCON_11 10.0961538462
R262 vdd_SDCON_3 vdd_SDCON_4 14.2045454545
R263 vdd_SDCON_3 vdd_SDCON_12 10.0961538462
R264 vdd_SDCON_4 vdd_SDCON_5 14.2045454545
R265 vdd_SDCON_4 vdd_SDCON_13 10.9375
R266 vdd_SDCON_5 vdd_SDCON_6 14.7727272727
R267 vdd_SDCON_5 vdd_SDCON_14 10.0961538462
R268 vdd_SDCON_6 vdd_SDCON_7 14.2045454545
R269 vdd_SDCON_6 vdd_SDCON_15 10.0961538462
R270 vdd_SDCON_7 vdd_SDCON_8 14.2045454545
R271 vdd_SDCON_7 vdd_SDCON_16 10.9375
R272 vdd_SDCON_8 vdd_SDCON_17 10.0961538462
R273 vdd_SDCON_9 vdd_SDCON_10 15.625
R274 vdd_SDCON_9 vdd_SDCON_18 10.0961538462
R275 vdd_SDCON_10 vdd_SDCON_11 15.625
R276 vdd_SDCON_10 vdd_SDCON_19 10.9375
R277 vdd_SDCON_11 vdd_SDCON_12 16.25
R278 vdd_SDCON_11 vdd_SDCON_20 10.0961538462
R279 vdd_SDCON_12 vdd_SDCON_13 15.625
R280 vdd_SDCON_12 vdd_SDCON_21 10.0961538462
R281 vdd_SDCON_13 vdd_SDCON_14 15.625
R282 vdd_SDCON_13 vdd_SDCON_22 10.9375
R283 vdd_SDCON_14 vdd_SDCON_15 16.25
R284 vdd_SDCON_14 vdd_SDCON_23 10.0961538462
R285 vdd_SDCON_15 vdd_SDCON_16 15.625
R286 vdd_SDCON_15 vdd_SDCON_24 10.0961538462
R287 vdd_SDCON_16 vdd_SDCON_17 15.625
R288 vdd_SDCON_16 vdd_SDCON_25 10.9375
R289 vdd_SDCON_17 vdd_SDCON_26 10.0961538462
R290 vdd_SDCON_18 vdd_SDCON_19 14.2045454545
R291 vdd_SDCON_19 vdd_SDCON_20 14.2045454545
R292 vdd_SDCON_20 vdd_SDCON_21 14.7727272727
R293 vdd_SDCON_21 vdd_SDCON_22 14.2045454545
R294 vdd_SDCON_22 vdd_SDCON_23 14.2045454545
R295 vdd_SDCON_23 vdd_SDCON_24 14.7727272727
R296 vdd_SDCON_24 vdd_SDCON_25 14.2045454545
R297 vdd_SDCON_25 vdd_SDCON_26 14.2045454545
R298 vdd_SDCON_27 vdd_SDCON_28 14.2045454545
R299 vdd_SDCON_27 vdd_SDCON_36 10.0961538462
R300 vdd_SDCON_28 vdd_SDCON_29 14.2045454545
R301 vdd_SDCON_28 vdd_SDCON_37 10.9375
R302 vdd_SDCON_29 vdd_SDCON_30 14.7727272727
R303 vdd_SDCON_29 vdd_SDCON_38 10.0961538462
R304 vdd_SDCON_30 vdd_SDCON_31 14.2045454545
R305 vdd_SDCON_30 vdd_SDCON_39 10.0961538462
R306 vdd_SDCON_31 vdd_SDCON_32 14.2045454545
R307 vdd_SDCON_31 vdd_SDCON_40 10.9375
R308 vdd_SDCON_32 vdd_SDCON_33 14.7727272727
R309 vdd_SDCON_32 vdd_SDCON_41 10.0961538462
R310 vdd_SDCON_33 vdd_SDCON_34 14.2045454545
R311 vdd_SDCON_33 vdd_SDCON_42 10.0961538462
R312 vdd_SDCON_34 vdd_SDCON_35 14.2045454545
R313 vdd_SDCON_34 vdd_SDCON_43 10.9375
R314 vdd_SDCON_35 vdd_SDCON_44 10.0961538462
R315 vdd_SDCON_36 vdd_SDCON_37 15.625
R316 vdd_SDCON_36 vdd_SDCON_45 10.0961538462
R317 vdd_SDCON_37 vdd_SDCON_38 15.625
R318 vdd_SDCON_37 vdd_SDCON_46 10.9375
R319 vdd_SDCON_38 vdd_SDCON_39 16.25
R320 vdd_SDCON_38 vdd_SDCON_47 10.0961538462
R321 vdd_SDCON_39 vdd_SDCON_40 15.625
R322 vdd_SDCON_39 vdd_SDCON_48 10.0961538462
R323 vdd_SDCON_40 vdd_SDCON_41 15.625
R324 vdd_SDCON_40 vdd_SDCON_49 10.9375
R325 vdd_SDCON_41 vdd_SDCON_42 16.25
R326 vdd_SDCON_41 vdd_SDCON_50 10.0961538462
R327 vdd_SDCON_42 vdd_SDCON_43 15.625
R328 vdd_SDCON_42 vdd_SDCON_51 10.0961538462
R329 vdd_SDCON_43 vdd_SDCON_44 15.625
R330 vdd_SDCON_43 vdd_SDCON_52 10.9375
R331 vdd_SDCON_44 vdd_SDCON_53 10.0961538462
R332 vdd_SDCON_45 vdd_SDCON_46 14.2045454545
R333 vdd_SDCON_46 vdd_SDCON_47 14.2045454545
R334 vdd_SDCON_47 vdd_SDCON_48 14.7727272727
R335 vdd_SDCON_48 vdd_SDCON_49 14.2045454545
R336 vdd_SDCON_49 vdd_SDCON_50 14.2045454545
R337 vdd_SDCON_50 vdd_SDCON_51 14.7727272727
R338 vdd_SDCON_51 vdd_SDCON_52 14.2045454545
R339 vdd_SDCON_52 vdd_SDCON_53 14.2045454545
R340 vdd_BPR_0 vdd_BPR_1 0.722242857143
R341 vdd_BPR_0 vdd_BPR_5 0.837630769231
R342 vdd_BPR_1 vdd_BPR_2 0.694464285714
R343 vdd_BPR_1 vdd_BPR_6 0.837630769231
R344 vdd_BPR_2 vdd_BPR_3 0.694464285714
R345 vdd_BPR_2 vdd_BPR_7 0.907433333333
R346 vdd_BPR_3 vdd_BPR_4 0.722242857143
R347 vdd_BPR_3 vdd_BPR_8 0.837630769231
R348 vdd_BPR_4 vdd_BPR_9 0.837630769231
R349 vdd_BPR_5 vdd_BPR_6 0.722242857143
R350 vdd_BPR_5 vdd_BPR_10 0.837630769231
R351 vdd_BPR_6 vdd_BPR_7 0.694464285714
R352 vdd_BPR_6 vdd_BPR_11 0.837630769231
R353 vdd_BPR_7 vdd_BPR_8 0.694464285714
R354 vdd_BPR_7 vdd_BPR_12 0.907433333333
R355 vdd_BPR_8 vdd_BPR_9 0.722242857143
R356 vdd_BPR_8 vdd_BPR_13 0.837630769231
R357 vdd_BPR_9 vdd_BPR_14 0.837630769231
R358 vdd_BPR_10 vdd_BPR_11 0.722242857143
R359 vdd_BPR_10 vdd_BPR_15 0.837630769231
R360 vdd_BPR_11 vdd_BPR_12 0.694464285714
R361 vdd_BPR_11 vdd_BPR_16 0.837630769231
R362 vdd_BPR_12 vdd_BPR_13 0.694464285714
R363 vdd_BPR_12 vdd_BPR_17 0.907433333333
R364 vdd_BPR_13 vdd_BPR_14 0.722242857143
R365 vdd_BPR_13 vdd_BPR_18 0.837630769231
R366 vdd_BPR_14 vdd_BPR_19 0.837630769231
R367 vdd_BPR_15 vdd_BPR_16 0.722242857143
R368 vdd_BPR_15 vdd_BPR_20 0.837630769231
R369 vdd_BPR_16 vdd_BPR_17 0.694464285714
R370 vdd_BPR_16 vdd_BPR_21 0.837630769231
R371 vdd_BPR_17 vdd_BPR_18 0.694464285714
R372 vdd_BPR_17 vdd_BPR_22 0.907433333333
R373 vdd_BPR_18 vdd_BPR_19 0.722242857143
R374 vdd_BPR_18 vdd_BPR_23 0.837630769231
R375 vdd_BPR_19 vdd_BPR_24 0.837630769231
R376 vdd_BPR_20 vdd_BPR_21 0.722242857143
R377 vdd_BPR_20 vdd_BPR_25 0.837630769231
R378 vdd_BPR_21 vdd_BPR_22 0.694464285714
R379 vdd_BPR_21 vdd_BPR_26 0.837630769231
R380 vdd_BPR_22 vdd_BPR_23 0.694464285714
R381 vdd_BPR_22 vdd_BPR_27 0.907433333333
R382 vdd_BPR_23 vdd_BPR_24 0.722242857143
R383 vdd_BPR_23 vdd_BPR_28 0.837630769231
R384 vdd_BPR_24 vdd_BPR_29 0.837630769231
R385 vdd_BPR_25 vdd_BPR_26 0.722242857143
R386 vdd_BPR_25 vdd_BPR_30 0.837630769231
R387 vdd_BPR_26 vdd_BPR_27 0.694464285714
R388 vdd_BPR_26 vdd_BPR_31 0.837630769231
R389 vdd_BPR_27 vdd_BPR_28 0.694464285714
R390 vdd_BPR_27 vdd_BPR_32 0.907433333333
R391 vdd_BPR_28 vdd_BPR_29 0.722242857143
R392 vdd_BPR_28 vdd_BPR_33 0.837630769231
R393 vdd_BPR_29 vdd_BPR_34 0.837630769231
R394 vdd_BPR_30 vdd_BPR_31 0.722242857143
R395 vdd_BPR_30 vdd_BPR_35 0.837630769231
R396 vdd_BPR_31 vdd_BPR_32 0.694464285714
R397 vdd_BPR_31 vdd_BPR_36 0.837630769231
R398 vdd_BPR_32 vdd_BPR_33 0.694464285714
R399 vdd_BPR_32 vdd_BPR_37 0.907433333333
R400 vdd_BPR_33 vdd_BPR_34 0.722242857143
R401 vdd_BPR_33 vdd_BPR_38 0.837630769231
R402 vdd_BPR_34 vdd_BPR_39 0.837630769231
R403 vdd_BPR_35 vdd_BPR_36 0.722242857143
R404 vdd_BPR_35 vdd_BPR_40 0.837630769231
R405 vdd_BPR_36 vdd_BPR_37 0.694464285714
R406 vdd_BPR_36 vdd_BPR_41 0.837630769231
R407 vdd_BPR_37 vdd_BPR_38 0.694464285714
R408 vdd_BPR_37 vdd 0.907433333333
R409 vdd_BPR_38 vdd_BPR_39 0.722242857143
R410 vdd_BPR_38 vdd_BPR_43 0.837630769231
R411 vdd_BPR_39 vdd_BPR_44 0.837630769231
R412 vdd_BPR_40 vdd_BPR_41 0.722242857143
R413 vdd_BPR_40 vdd_BPR_45 0.837630769231
R414 vdd_BPR_41 vdd 0.694464285714
R415 vdd_BPR_41 vdd_BPR_46 0.837630769231
R416 vdd vdd_BPR_43 0.694464285714
R417 vdd vdd_BPR_47 0.907433333333
R418 vdd_BPR_43 vdd_BPR_44 0.722242857143
R419 vdd_BPR_43 vdd_BPR_48 0.837630769231
R420 vdd_BPR_44 vdd_BPR_49 0.837630769231
R421 vdd_BPR_45 vdd_BPR_46 0.722242857143
R422 vdd_BPR_45 vdd_BPR_50 0.837630769231
R423 vdd_BPR_46 vdd_BPR_47 0.694464285714
R424 vdd_BPR_46 vdd_BPR_51 0.837630769231
R425 vdd_BPR_47 vdd_BPR_48 0.694464285714
R426 vdd_BPR_47 vdd_BPR_52 0.907433333333
R427 vdd_BPR_48 vdd_BPR_49 0.722242857143
R428 vdd_BPR_48 vdd_BPR_53 0.837630769231
R429 vdd_BPR_49 vdd_BPR_54 0.837630769231
R430 vdd_BPR_50 vdd_BPR_51 0.722242857143
R431 vdd_BPR_50 vdd_BPR_55 0.837630769231
R432 vdd_BPR_51 vdd_BPR_52 0.694464285714
R433 vdd_BPR_51 vdd_BPR_56 0.837630769231
R434 vdd_BPR_52 vdd_BPR_53 0.694464285714
R435 vdd_BPR_52 vdd_BPR_57 0.907433333333
R436 vdd_BPR_53 vdd_BPR_54 0.722242857143
R437 vdd_BPR_53 vdd_BPR_58 0.837630769231
R438 vdd_BPR_54 vdd_BPR_59 0.837630769231
R439 vdd_BPR_55 vdd_BPR_56 0.722242857143
R440 vdd_BPR_55 vdd_BPR_60 0.837630769231
R441 vdd_BPR_56 vdd_BPR_57 0.694464285714
R442 vdd_BPR_56 vdd_BPR_61 0.837630769231
R443 vdd_BPR_57 vdd_BPR_58 0.694464285714
R444 vdd_BPR_57 vdd_BPR_62 0.907433333333
R445 vdd_BPR_58 vdd_BPR_59 0.722242857143
R446 vdd_BPR_58 vdd_BPR_63 0.837630769231
R447 vdd_BPR_59 vdd_BPR_64 0.837630769231
R448 vdd_BPR_60 vdd_BPR_61 0.722242857143
R449 vdd_BPR_60 vdd_BPR_65 0.837630769231
R450 vdd_BPR_61 vdd_BPR_62 0.694464285714
R451 vdd_BPR_61 vdd_BPR_66 0.837630769231
R452 vdd_BPR_62 vdd_BPR_63 0.694464285714
R453 vdd_BPR_62 vdd_BPR_67 0.907433333333
R454 vdd_BPR_63 vdd_BPR_64 0.722242857143
R455 vdd_BPR_63 vdd_BPR_68 0.837630769231
R456 vdd_BPR_64 vdd_BPR_69 0.837630769231
R457 vdd_BPR_65 vdd_BPR_66 0.722242857143
R458 vdd_BPR_65 vdd_BPR_70 0.837630769231
R459 vdd_BPR_66 vdd_BPR_67 0.694464285714
R460 vdd_BPR_66 vdd_BPR_71 0.837630769231
R461 vdd_BPR_67 vdd_BPR_68 0.694464285714
R462 vdd_BPR_67 vdd_BPR_72 0.907433333333
R463 vdd_BPR_68 vdd_BPR_69 0.722242857143
R464 vdd_BPR_68 vdd_BPR_73 0.837630769231
R465 vdd_BPR_69 vdd_BPR_74 0.837630769231
R466 vdd_BPR_70 vdd_BPR_71 0.722242857143
R467 vdd_BPR_70 vdd_BPR_75 0.837630769231
R468 vdd_BPR_71 vdd_BPR_72 0.694464285714
R469 vdd_BPR_71 vdd_BPR_76 0.837630769231
R470 vdd_BPR_72 vdd_BPR_73 0.694464285714
R471 vdd_BPR_72 vdd_BPR_77 0.907433333333
R472 vdd_BPR_73 vdd_BPR_74 0.722242857143
R473 vdd_BPR_73 vdd_BPR_78 0.837630769231
R474 vdd_BPR_74 vdd_BPR_79 0.837630769231
R475 vdd_BPR_75 vdd_BPR_76 0.722242857143
R476 vdd_BPR_75 vdd_BPR_80 0.837630769231
R477 vdd_BPR_76 vdd_BPR_77 0.694464285714
R478 vdd_BPR_76 vdd_BPR_81 0.837630769231
R479 vdd_BPR_77 vdd_BPR_78 0.694464285714
R480 vdd_BPR_77 vdd_BPR_82 0.907433333333
R481 vdd_BPR_78 vdd_BPR_79 0.722242857143
R482 vdd_BPR_78 vdd_BPR_83 0.837630769231
R483 vdd_BPR_79 vdd_BPR_84 0.837630769231
R484 vdd_BPR_80 vdd_BPR_81 0.722242857143
R485 vdd_BPR_80 vdd_BPR_85 0.837630769231
R486 vdd_BPR_81 vdd_BPR_82 0.694464285714
R487 vdd_BPR_81 vdd_BPR_86 0.837630769231
R488 vdd_BPR_82 vdd_BPR_83 0.694464285714
R489 vdd_BPR_82 vdd_BPR_87 0.907433333333
R490 vdd_BPR_83 vdd_BPR_84 0.722242857143
R491 vdd_BPR_83 vdd_BPR_88 0.837630769231
R492 vdd_BPR_84 vdd_BPR_89 0.837630769231
R493 vdd_BPR_85 vdd_BPR_86 0.722242857143
R494 vdd_BPR_86 vdd_BPR_87 0.694464285714
R495 vdd_BPR_87 vdd_BPR_88 0.694464285714
R496 vdd_BPR_88 vdd_BPR_89 0.722242857143
R497 vdd_BPR_10 vdd_SDCON_17 30
R498 vdd_BPR_70 vdd_SDCON_44 30
R499 vss_SDCON_0 vss_SDCON_1 14.2045454545
R500 vss_SDCON_0 vss_SDCON_9 10.0961538462
R501 vss_SDCON_1 vss_SDCON_2 14.2045454545
R502 vss_SDCON_1 vss_SDCON_10 10.9375
R503 vss_SDCON_2 vss_SDCON_3 14.7727272727
R504 vss_SDCON_2 vss_SDCON_11 10.0961538462
R505 vss_SDCON_3 vss_SDCON_4 14.2045454545
R506 vss_SDCON_3 vss_SDCON_12 10.0961538462
R507 vss_SDCON_4 vss_SDCON_5 14.2045454545
R508 vss_SDCON_4 vss_SDCON_13 10.9375
R509 vss_SDCON_5 vss_SDCON_6 14.7727272727
R510 vss_SDCON_5 vss_SDCON_14 10.0961538462
R511 vss_SDCON_6 vss_SDCON_7 14.2045454545
R512 vss_SDCON_6 vss_SDCON_15 10.0961538462
R513 vss_SDCON_7 vss_SDCON_8 14.2045454545
R514 vss_SDCON_7 vss_SDCON_16 10.9375
R515 vss_SDCON_8 vss_SDCON_17 10.0961538462
R516 vss_SDCON_9 vss_SDCON_10 15.625
R517 vss_SDCON_9 vss_SDCON_18 10.0961538462
R518 vss_SDCON_10 vss_SDCON_11 15.625
R519 vss_SDCON_10 vss_SDCON_19 10.9375
R520 vss_SDCON_11 vss_SDCON_12 16.25
R521 vss_SDCON_11 vss_SDCON_20 10.0961538462
R522 vss_SDCON_12 vss_SDCON_13 15.625
R523 vss_SDCON_12 vss_SDCON_21 10.0961538462
R524 vss_SDCON_13 vss_SDCON_14 15.625
R525 vss_SDCON_13 vss_SDCON_22 10.9375
R526 vss_SDCON_14 vss_SDCON_15 16.25
R527 vss_SDCON_14 vss_SDCON_23 10.0961538462
R528 vss_SDCON_15 vss_SDCON_16 15.625
R529 vss_SDCON_15 vss_SDCON_24 10.0961538462
R530 vss_SDCON_16 vss_SDCON_17 15.625
R531 vss_SDCON_16 vss_SDCON_25 10.9375
R532 vss_SDCON_17 vss_SDCON_26 10.0961538462
R533 vss_SDCON_18 vss_SDCON_19 14.2045454545
R534 vss_SDCON_19 vss_SDCON_20 14.2045454545
R535 vss_SDCON_20 vss_SDCON_21 14.7727272727
R536 vss_SDCON_21 vss_SDCON_22 14.2045454545
R537 vss_SDCON_22 vss_SDCON_23 14.2045454545
R538 vss_SDCON_23 vss_SDCON_24 14.7727272727
R539 vss_SDCON_24 vss_SDCON_25 14.2045454545
R540 vss_SDCON_25 vss_SDCON_26 14.2045454545
R541 vss_SDCON_27 vss_SDCON_28 14.2045454545
R542 vss_SDCON_27 vss_SDCON_36 10.0961538462
R543 vss_SDCON_28 vss_SDCON_29 14.2045454545
R544 vss_SDCON_28 vss_SDCON_37 10.9375
R545 vss_SDCON_29 vss_SDCON_30 14.7727272727
R546 vss_SDCON_29 vss_SDCON_38 10.0961538462
R547 vss_SDCON_30 vss_SDCON_31 14.2045454545
R548 vss_SDCON_30 vss_SDCON_39 10.0961538462
R549 vss_SDCON_31 vss_SDCON_32 14.2045454545
R550 vss_SDCON_31 vss_SDCON_40 10.9375
R551 vss_SDCON_32 vss_SDCON_33 14.7727272727
R552 vss_SDCON_32 vss_SDCON_41 10.0961538462
R553 vss_SDCON_33 vss_SDCON_34 14.2045454545
R554 vss_SDCON_33 vss_SDCON_42 10.0961538462
R555 vss_SDCON_34 vss_SDCON_35 14.2045454545
R556 vss_SDCON_34 vss_SDCON_43 10.9375
R557 vss_SDCON_35 vss_SDCON_44 10.0961538462
R558 vss_SDCON_36 vss_SDCON_37 15.625
R559 vss_SDCON_36 vss_SDCON_45 10.0961538462
R560 vss_SDCON_37 vss_SDCON_38 15.625
R561 vss_SDCON_37 vss_SDCON_46 10.9375
R562 vss_SDCON_38 vss_SDCON_39 16.25
R563 vss_SDCON_38 vss_SDCON_47 10.0961538462
R564 vss_SDCON_39 vss_SDCON_40 15.625
R565 vss_SDCON_39 vss_SDCON_48 10.0961538462
R566 vss_SDCON_40 vss_SDCON_41 15.625
R567 vss_SDCON_40 vss_SDCON_49 10.9375
R568 vss_SDCON_41 vss_SDCON_42 16.25
R569 vss_SDCON_41 vss_SDCON_50 10.0961538462
R570 vss_SDCON_42 vss_SDCON_43 15.625
R571 vss_SDCON_42 vss_SDCON_51 10.0961538462
R572 vss_SDCON_43 vss_SDCON_44 15.625
R573 vss_SDCON_43 vss_SDCON_52 10.9375
R574 vss_SDCON_44 vss_SDCON_53 10.0961538462
R575 vss_SDCON_45 vss_SDCON_46 14.2045454545
R576 vss_SDCON_46 vss_SDCON_47 14.2045454545
R577 vss_SDCON_47 vss_SDCON_48 14.7727272727
R578 vss_SDCON_48 vss_SDCON_49 14.2045454545
R579 vss_SDCON_49 vss_SDCON_50 14.2045454545
R580 vss_SDCON_50 vss_SDCON_51 14.7727272727
R581 vss_SDCON_51 vss_SDCON_52 14.2045454545
R582 vss_SDCON_52 vss_SDCON_53 14.2045454545
R583 vss_BPR_0 vss_BPR_1 0.722242857143
R584 vss_BPR_0 vss_BPR_5 0.837630769231
R585 vss_BPR_1 vss_BPR_2 0.694464285714
R586 vss_BPR_1 vss_BPR_6 0.837630769231
R587 vss_BPR_2 vss_BPR_3 0.694464285714
R588 vss_BPR_2 vss_BPR_7 0.907433333333
R589 vss_BPR_3 vss_BPR_4 0.722242857143
R590 vss_BPR_3 vss_BPR_8 0.837630769231
R591 vss_BPR_4 vss_BPR_9 0.837630769231
R592 vss_BPR_5 vss_BPR_6 0.722242857143
R593 vss_BPR_5 vss_BPR_10 0.837630769231
R594 vss_BPR_6 vss_BPR_7 0.694464285714
R595 vss_BPR_6 vss_BPR_11 0.837630769231
R596 vss_BPR_7 vss_BPR_8 0.694464285714
R597 vss_BPR_7 vss_BPR_12 0.907433333333
R598 vss_BPR_8 vss_BPR_9 0.722242857143
R599 vss_BPR_8 vss_BPR_13 0.837630769231
R600 vss_BPR_9 vss_BPR_14 0.837630769231
R601 vss_BPR_10 vss_BPR_11 0.722242857143
R602 vss_BPR_10 vss_BPR_15 0.837630769231
R603 vss_BPR_11 vss_BPR_12 0.694464285714
R604 vss_BPR_11 vss_BPR_16 0.837630769231
R605 vss_BPR_12 vss_BPR_13 0.694464285714
R606 vss_BPR_12 vss_BPR_17 0.907433333333
R607 vss_BPR_13 vss_BPR_14 0.722242857143
R608 vss_BPR_13 vss_BPR_18 0.837630769231
R609 vss_BPR_14 vss_BPR_19 0.837630769231
R610 vss_BPR_15 vss_BPR_16 0.722242857143
R611 vss_BPR_15 vss_BPR_20 0.837630769231
R612 vss_BPR_16 vss_BPR_17 0.694464285714
R613 vss_BPR_16 vss_BPR_21 0.837630769231
R614 vss_BPR_17 vss_BPR_18 0.694464285714
R615 vss_BPR_17 vss_BPR_22 0.907433333333
R616 vss_BPR_18 vss_BPR_19 0.722242857143
R617 vss_BPR_18 vss_BPR_23 0.837630769231
R618 vss_BPR_19 vss_BPR_24 0.837630769231
R619 vss_BPR_20 vss_BPR_21 0.722242857143
R620 vss_BPR_20 vss_BPR_25 0.837630769231
R621 vss_BPR_21 vss_BPR_22 0.694464285714
R622 vss_BPR_21 vss_BPR_26 0.837630769231
R623 vss_BPR_22 vss_BPR_23 0.694464285714
R624 vss_BPR_22 vss_BPR_27 0.907433333333
R625 vss_BPR_23 vss_BPR_24 0.722242857143
R626 vss_BPR_23 vss_BPR_28 0.837630769231
R627 vss_BPR_24 vss_BPR_29 0.837630769231
R628 vss_BPR_25 vss_BPR_26 0.722242857143
R629 vss_BPR_25 vss_BPR_30 0.837630769231
R630 vss_BPR_26 vss_BPR_27 0.694464285714
R631 vss_BPR_26 vss_BPR_31 0.837630769231
R632 vss_BPR_27 vss_BPR_28 0.694464285714
R633 vss_BPR_27 vss_BPR_32 0.907433333333
R634 vss_BPR_28 vss_BPR_29 0.722242857143
R635 vss_BPR_28 vss_BPR_33 0.837630769231
R636 vss_BPR_29 vss_BPR_34 0.837630769231
R637 vss_BPR_30 vss_BPR_31 0.722242857143
R638 vss_BPR_30 vss_BPR_35 0.837630769231
R639 vss_BPR_31 vss_BPR_32 0.694464285714
R640 vss_BPR_31 vss_BPR_36 0.837630769231
R641 vss_BPR_32 vss_BPR_33 0.694464285714
R642 vss_BPR_32 vss_BPR_37 0.907433333333
R643 vss_BPR_33 vss_BPR_34 0.722242857143
R644 vss_BPR_33 vss_BPR_38 0.837630769231
R645 vss_BPR_34 vss_BPR_39 0.837630769231
R646 vss_BPR_35 vss_BPR_36 0.722242857143
R647 vss_BPR_35 vss_BPR_40 0.837630769231
R648 vss_BPR_36 vss_BPR_37 0.694464285714
R649 vss_BPR_36 vss_BPR_41 0.837630769231
R650 vss_BPR_37 vss_BPR_38 0.694464285714
R651 vss_BPR_37 vss 0.907433333333
R652 vss_BPR_38 vss_BPR_39 0.722242857143
R653 vss_BPR_38 vss_BPR_43 0.837630769231
R654 vss_BPR_39 vss_BPR_44 0.837630769231
R655 vss_BPR_40 vss_BPR_41 0.722242857143
R656 vss_BPR_40 vss_BPR_45 0.837630769231
R657 vss_BPR_41 vss 0.694464285714
R658 vss_BPR_41 vss_BPR_46 0.837630769231
R659 vss vss_BPR_43 0.694464285714
R660 vss vss_BPR_47 0.907433333333
R661 vss_BPR_43 vss_BPR_44 0.722242857143
R662 vss_BPR_43 vss_BPR_48 0.837630769231
R663 vss_BPR_44 vss_BPR_49 0.837630769231
R664 vss_BPR_45 vss_BPR_46 0.722242857143
R665 vss_BPR_45 vss_BPR_50 0.837630769231
R666 vss_BPR_46 vss_BPR_47 0.694464285714
R667 vss_BPR_46 vss_BPR_51 0.837630769231
R668 vss_BPR_47 vss_BPR_48 0.694464285714
R669 vss_BPR_47 vss_BPR_52 0.907433333333
R670 vss_BPR_48 vss_BPR_49 0.722242857143
R671 vss_BPR_48 vss_BPR_53 0.837630769231
R672 vss_BPR_49 vss_BPR_54 0.837630769231
R673 vss_BPR_50 vss_BPR_51 0.722242857143
R674 vss_BPR_50 vss_BPR_55 0.837630769231
R675 vss_BPR_51 vss_BPR_52 0.694464285714
R676 vss_BPR_51 vss_BPR_56 0.837630769231
R677 vss_BPR_52 vss_BPR_53 0.694464285714
R678 vss_BPR_52 vss_BPR_57 0.907433333333
R679 vss_BPR_53 vss_BPR_54 0.722242857143
R680 vss_BPR_53 vss_BPR_58 0.837630769231
R681 vss_BPR_54 vss_BPR_59 0.837630769231
R682 vss_BPR_55 vss_BPR_56 0.722242857143
R683 vss_BPR_55 vss_BPR_60 0.837630769231
R684 vss_BPR_56 vss_BPR_57 0.694464285714
R685 vss_BPR_56 vss_BPR_61 0.837630769231
R686 vss_BPR_57 vss_BPR_58 0.694464285714
R687 vss_BPR_57 vss_BPR_62 0.907433333333
R688 vss_BPR_58 vss_BPR_59 0.722242857143
R689 vss_BPR_58 vss_BPR_63 0.837630769231
R690 vss_BPR_59 vss_BPR_64 0.837630769231
R691 vss_BPR_60 vss_BPR_61 0.722242857143
R692 vss_BPR_60 vss_BPR_65 0.837630769231
R693 vss_BPR_61 vss_BPR_62 0.694464285714
R694 vss_BPR_61 vss_BPR_66 0.837630769231
R695 vss_BPR_62 vss_BPR_63 0.694464285714
R696 vss_BPR_62 vss_BPR_67 0.907433333333
R697 vss_BPR_63 vss_BPR_64 0.722242857143
R698 vss_BPR_63 vss_BPR_68 0.837630769231
R699 vss_BPR_64 vss_BPR_69 0.837630769231
R700 vss_BPR_65 vss_BPR_66 0.722242857143
R701 vss_BPR_65 vss_BPR_70 0.837630769231
R702 vss_BPR_66 vss_BPR_67 0.694464285714
R703 vss_BPR_66 vss_BPR_71 0.837630769231
R704 vss_BPR_67 vss_BPR_68 0.694464285714
R705 vss_BPR_67 vss_BPR_72 0.907433333333
R706 vss_BPR_68 vss_BPR_69 0.722242857143
R707 vss_BPR_68 vss_BPR_73 0.837630769231
R708 vss_BPR_69 vss_BPR_74 0.837630769231
R709 vss_BPR_70 vss_BPR_71 0.722242857143
R710 vss_BPR_70 vss_BPR_75 0.837630769231
R711 vss_BPR_71 vss_BPR_72 0.694464285714
R712 vss_BPR_71 vss_BPR_76 0.837630769231
R713 vss_BPR_72 vss_BPR_73 0.694464285714
R714 vss_BPR_72 vss_BPR_77 0.907433333333
R715 vss_BPR_73 vss_BPR_74 0.722242857143
R716 vss_BPR_73 vss_BPR_78 0.837630769231
R717 vss_BPR_74 vss_BPR_79 0.837630769231
R718 vss_BPR_75 vss_BPR_76 0.722242857143
R719 vss_BPR_75 vss_BPR_80 0.837630769231
R720 vss_BPR_76 vss_BPR_77 0.694464285714
R721 vss_BPR_76 vss_BPR_81 0.837630769231
R722 vss_BPR_77 vss_BPR_78 0.694464285714
R723 vss_BPR_77 vss_BPR_82 0.907433333333
R724 vss_BPR_78 vss_BPR_79 0.722242857143
R725 vss_BPR_78 vss_BPR_83 0.837630769231
R726 vss_BPR_79 vss_BPR_84 0.837630769231
R727 vss_BPR_80 vss_BPR_81 0.722242857143
R728 vss_BPR_80 vss_BPR_85 0.837630769231
R729 vss_BPR_81 vss_BPR_82 0.694464285714
R730 vss_BPR_81 vss_BPR_86 0.837630769231
R731 vss_BPR_82 vss_BPR_83 0.694464285714
R732 vss_BPR_82 vss_BPR_87 0.907433333333
R733 vss_BPR_83 vss_BPR_84 0.722242857143
R734 vss_BPR_83 vss_BPR_88 0.837630769231
R735 vss_BPR_84 vss_BPR_89 0.837630769231
R736 vss_BPR_85 vss_BPR_86 0.722242857143
R737 vss_BPR_86 vss_BPR_87 0.694464285714
R738 vss_BPR_87 vss_BPR_88 0.694464285714
R739 vss_BPR_88 vss_BPR_89 0.722242857143
R740 vss_BPR_14 vss_SDCON_9 30
R741 vss_BPR_74 vss_SDCON_36 30
C0_1 net12_M1_10 net7_M1_10 6.26551e-18
C0_2 net12_M1_10 vdd 2.7141e-18
C0_3 net12_M1_10 vss 2.183665e-18
C0_ref net12_M1_10 vss 5.423125e-18
C1_2 net7_M1_10 vdd 2.181955e-18
C1_3 net7_M1_10 vss 2.711365e-18
C1_ref net7_M1_10 vss 5.43077e-18
C2_3 vdd vss 7.561775e-18
C2_ref vdd vss 1.498617e-17
.ENDS decap_rc

XI ideal_vdd 0 decap_ideal
XR rc_vdd 0 decap_rc
VIDEAL ideal_vdd 0 DC 0.6 AC 1
VRC rc_vdd 0 DC 0.6 AC 1
.OPTIONS DEVICE TEMP=125 GMIN=1e-15
.OPTIONS NONLIN ABSTOL=1e-15 RELTOL=1e-8 RHSTOL=1e-14
.OP
.AC DEC 10 1e6 1e12
.PRINT AC FORMAT=CSV PRECISION=15 IR(VIDEAL) II(VIDEAL) IR(VRC) II(VRC)
.PRINT AC_IC FORMAT=CSV PRECISION=15 I(VIDEAL) I(VRC) V(XI:net7) V(XI:net12)
.END
