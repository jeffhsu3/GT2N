.subckt gt2_6t_decapcc_sg_w31_hvt vdd vss
*.PININFO vdd:B vss:B
MM1 net7 net12 vss vss nmos_hvt W=0.031u L=0.014u M=1
MM0 net12 net7 vdd vdd pmos_hvt W=0.031u L=0.014u M=1
.ends gt2_6t_decapcc_sg_w31_hvt

.SUBCKT gt2_6t_decapcc_sg_w31_hvt_array vdd vss
X00 vdd vss gt2_6t_decapcc_sg_w31_hvt
X10 vdd vss gt2_6t_decapcc_sg_w31_hvt
X20 vdd vss gt2_6t_decapcc_sg_w31_hvt
X01 vdd vss gt2_6t_decapcc_sg_w31_hvt
X11 vdd vss gt2_6t_decapcc_sg_w31_hvt
X21 vdd vss gt2_6t_decapcc_sg_w31_hvt
X02 vdd vss gt2_6t_decapcc_sg_w31_hvt
X12 vdd vss gt2_6t_decapcc_sg_w31_hvt
X22 vdd vss gt2_6t_decapcc_sg_w31_hvt
.ENDS gt2_6t_decapcc_sg_w31_hvt_array
