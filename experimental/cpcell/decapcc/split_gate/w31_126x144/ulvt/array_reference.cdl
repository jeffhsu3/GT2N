.subckt gt2_6t_decapcc_sg_w31_ulvt vdd vss
*.PININFO vdd:B vss:B
MM1 net7 net12 vss vss nmos_ulvt W=0.031u L=0.014u M=1
MM0 net12 net7 vdd vdd pmos_ulvt W=0.031u L=0.014u M=1
.ends gt2_6t_decapcc_sg_w31_ulvt

.SUBCKT gt2_6t_decapcc_sg_w31_ulvt_array vdd vss
X00 vdd vss gt2_6t_decapcc_sg_w31_ulvt
X10 vdd vss gt2_6t_decapcc_sg_w31_ulvt
X20 vdd vss gt2_6t_decapcc_sg_w31_ulvt
X01 vdd vss gt2_6t_decapcc_sg_w31_ulvt
X11 vdd vss gt2_6t_decapcc_sg_w31_ulvt
X21 vdd vss gt2_6t_decapcc_sg_w31_ulvt
X02 vdd vss gt2_6t_decapcc_sg_w31_ulvt
X12 vdd vss gt2_6t_decapcc_sg_w31_ulvt
X22 vdd vss gt2_6t_decapcc_sg_w31_ulvt
.ENDS gt2_6t_decapcc_sg_w31_ulvt_array
