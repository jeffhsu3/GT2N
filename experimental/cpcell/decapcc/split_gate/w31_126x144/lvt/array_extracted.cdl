* GT2N extracted

.SUBCKT gt2_6t_decapcc_sg_w31_lvt_array vdd vss
X$1 vss vdd gt2_6t_decapcc_sg_w31_lvt
X$2 vss vdd gt2_6t_decapcc_sg_w31_lvt
X$3 vss vdd gt2_6t_decapcc_sg_w31_lvt
X$4 vss vdd gt2_6t_decapcc_sg_w31_lvt
X$5 vss vdd gt2_6t_decapcc_sg_w31_lvt
X$6 vss vdd gt2_6t_decapcc_sg_w31_lvt
X$7 vss vdd gt2_6t_decapcc_sg_w31_lvt
X$8 vss vdd gt2_6t_decapcc_sg_w31_lvt
X$9 vss vdd gt2_6t_decapcc_sg_w31_lvt
.ENDS gt2_6t_decapcc_sg_w31_lvt_array

.SUBCKT gt2_6t_decapcc_sg_w31_lvt vss vdd
M$1 \$3 \$4 vss vss nmos_lvt L=0.014U W=0.031U AS=0.000868P AD=0.000868P
+ PS=0.118U PD=0.118U
M$2 vdd \$3 \$4 vdd pmos_lvt L=0.014U W=0.031U AS=0.000868P AD=0.000868P
+ PS=0.118U PD=0.118U
.ENDS gt2_6t_decapcc_sg_w31_lvt
