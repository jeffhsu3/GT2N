* GT2N extracted

.SUBCKT gt2_6t_decapcc_sg_w31_elvt_rowend A_4_0 Y_4_0 A_4_1 Y_4_1 A_4_2 Y_4_2
+ vss vdd
X$1 vss vdd Y_4_0 A_4_0 gt2_6t_inv_x1_w31_elvt
X$2 vss vdd Y_4_1 A_4_1 gt2_6t_inv_x1_w31_elvt
X$3 vss vdd Y_4_2 A_4_2 gt2_6t_inv_x1_w31_elvt
X$5 vss vdd gt2_6t_decapcc_sg_w31_elvt
X$7 vss vdd gt2_6t_decapcc_sg_w31_elvt
X$8 vss vdd gt2_6t_decapcc_sg_w31_elvt
X$12 vss vdd gt2_6t_decapcc_sg_w31_elvt
X$14 vss vdd gt2_6t_decapcc_sg_w31_elvt
X$17 vss vdd gt2_6t_decapcc_sg_w31_elvt
X$18 vss vdd gt2_6t_decapcc_sg_w31_elvt
X$19 vss vdd gt2_6t_decapcc_sg_w31_elvt
X$20 vss vdd gt2_6t_decapcc_sg_w31_elvt
.ENDS gt2_6t_decapcc_sg_w31_elvt_rowend

.SUBCKT gt2_6t_inv_x1_w31_elvt vss vdd Y A
M$1 Y A vss vss nmos_elvt L=0.014U W=0.031U AS=0.000868P AD=0.000868P PS=0.118U
+ PD=0.118U
M$2 Y A vdd vdd pmos_elvt L=0.014U W=0.031U AS=0.000868P AD=0.000868P PS=0.118U
+ PD=0.118U
.ENDS gt2_6t_inv_x1_w31_elvt

.SUBCKT gt2_6t_decapcc_sg_w31_elvt vss vdd
M$1 \$3 \$4 vss vss nmos_elvt L=0.014U W=0.031U AS=0.000868P AD=0.000868P
+ PS=0.118U PD=0.118U
M$2 vdd \$3 \$4 vdd pmos_elvt L=0.014U W=0.031U AS=0.000868P AD=0.000868P
+ PS=0.118U PD=0.118U
.ENDS gt2_6t_decapcc_sg_w31_elvt
