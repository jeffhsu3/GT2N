.subckt gt2_6t_decapcc_sg_w31_elvt vdd vss
*.PININFO vdd:B vss:B
MM1 net7 net12 vss vss nmos_elvt W=0.031u L=0.014u M=1
MM0 net12 net7 vdd vdd pmos_elvt W=0.031u L=0.014u M=1
.ends gt2_6t_decapcc_sg_w31_elvt

.subckt gt2_6t_inv_x1_w31_elvt A Y vdd vss
*.PININFO A:I Y:O vdd:B vss:B
MM0 Y A vdd vdd pmos_elvt W=0.031u L=0.014u M=1
MM1 Y A vss vss nmos_elvt W=0.031u L=0.014u M=1
.ends gt2_6t_inv_x1_w31_elvt

.SUBCKT gt2_6t_decapcc_sg_w31_elvt_mixed A_0_0 Y_0_0 A_2_0 Y_2_0 A_0_1 Y_0_1 A_2_1 Y_2_1 A_0_2 Y_0_2 A_2_2 Y_2_2 vdd vss
X00 A_0_0 Y_0_0 vdd vss gt2_6t_inv_x1_w31_elvt
X10  vdd vss gt2_6t_decapcc_sg_w31_elvt
X20 A_2_0 Y_2_0 vdd vss gt2_6t_inv_x1_w31_elvt
X01 A_0_1 Y_0_1 vdd vss gt2_6t_inv_x1_w31_elvt
X11  vdd vss gt2_6t_decapcc_sg_w31_elvt
X21 A_2_1 Y_2_1 vdd vss gt2_6t_inv_x1_w31_elvt
X02 A_0_2 Y_0_2 vdd vss gt2_6t_inv_x1_w31_elvt
X12  vdd vss gt2_6t_decapcc_sg_w31_elvt
X22 A_2_2 Y_2_2 vdd vss gt2_6t_inv_x1_w31_elvt
.ENDS gt2_6t_decapcc_sg_w31_elvt_mixed
