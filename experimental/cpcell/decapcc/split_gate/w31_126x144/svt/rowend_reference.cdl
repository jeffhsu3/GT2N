.subckt gt2_6t_decapcc_sg_w31_svt vdd vss
*.PININFO vdd:B vss:B
MM1 net7 net12 vss vss nmos_svt W=0.031u L=0.014u M=1
MM0 net12 net7 vdd vdd pmos_svt W=0.031u L=0.014u M=1
.ends gt2_6t_decapcc_sg_w31_svt

.subckt gt2_6t_inv_x1_w31_svt A Y vdd vss
*.PININFO A:I Y:O vdd:B vss:B
MM0 Y A vdd vdd pmos_svt W=0.031u L=0.014u M=1
MM1 Y A vss vss nmos_svt W=0.031u L=0.014u M=1
.ends gt2_6t_inv_x1_w31_svt

.subckt gt2_6t_tapbspdn_w13_svt vdd vss
.ends gt2_6t_tapbspdn_w13_svt

.subckt gt2_6t_filler_w13_svt vdd vss
.ends gt2_6t_filler_w13_svt

.SUBCKT gt2_6t_decapcc_sg_w31_svt_rowend A_4_0 Y_4_0 A_4_1 Y_4_1 A_4_2 Y_4_2 vdd vss
X00  vdd vss gt2_6t_tapbspdn_w13_svt
X10  vdd vss gt2_6t_decapcc_sg_w31_svt
X20  vdd vss gt2_6t_filler_w13_svt
X30  vdd vss gt2_6t_decapcc_sg_w31_svt
X40 A_4_0 Y_4_0 vdd vss gt2_6t_inv_x1_w31_svt
X50  vdd vss gt2_6t_decapcc_sg_w31_svt
X60  vdd vss gt2_6t_filler_w13_svt
X70  vdd vss gt2_6t_tapbspdn_w13_svt
X01  vdd vss gt2_6t_tapbspdn_w13_svt
X11  vdd vss gt2_6t_decapcc_sg_w31_svt
X21  vdd vss gt2_6t_filler_w13_svt
X31  vdd vss gt2_6t_decapcc_sg_w31_svt
X41 A_4_1 Y_4_1 vdd vss gt2_6t_inv_x1_w31_svt
X51  vdd vss gt2_6t_decapcc_sg_w31_svt
X61  vdd vss gt2_6t_filler_w13_svt
X71  vdd vss gt2_6t_tapbspdn_w13_svt
X02  vdd vss gt2_6t_tapbspdn_w13_svt
X12  vdd vss gt2_6t_decapcc_sg_w31_svt
X22  vdd vss gt2_6t_filler_w13_svt
X32  vdd vss gt2_6t_decapcc_sg_w31_svt
X42 A_4_2 Y_4_2 vdd vss gt2_6t_inv_x1_w31_svt
X52  vdd vss gt2_6t_decapcc_sg_w31_svt
X62  vdd vss gt2_6t_filler_w13_svt
X72  vdd vss gt2_6t_tapbspdn_w13_svt
.ENDS gt2_6t_decapcc_sg_w31_svt_rowend
