.subckt gt2n_split_decap_w13_h144_lvt vdd vss
*.PININFO vdd:B vss:B
MM1 net7 net12 vss vss nmos_lvt W=0.013u L=0.014u M=1
MM0 net12 net7 vdd vdd pmos_lvt W=0.013u L=0.014u M=1
.ends gt2n_split_decap_w13_h144_lvt
